* Sensitivity-grade testbench body for osc_nmos (circuit body only: klt sim owns .control/.end).
* SIMULATION: schematic-level netlist design/osc_bank/osc_nmos.spice, the klt pex schematic-side DUT; the extracted leg re-points the single .include.
* Enable is a behavioural source that follows v(vdd), so it swings rail to rail at every swept
* supply (an explicit PULSE could not be swept with the supply in a Monte Carlo `units` request).
* It is off for 1 ns and then ramps to v(vdd) over 100 ps.
.include "../../../design/osc_bank/osc_nmos.spice"
Vdd vdd 0 1.8
Vss vss 0 0
Ben en 0 V='v(vdd)*min(max((time-1n)/100p,0),1)'
Xdut en out vdd vss osc_nmos
* Probe variant (issue #32): same bench plus relaxed solver options, as #69's tb_osc_wire_probe.spice.
.options reltol=0.01 gmin=1e-10 method=gear

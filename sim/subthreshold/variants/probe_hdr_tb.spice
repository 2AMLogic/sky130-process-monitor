* HEADER DEVICE PROBE for the osc_subth cold-corner iteration (circuit body for `klt sim`;
* generated by gen_variants.py; the gen_probe.py convention: |Vgs| swept by Vg,
* |Vds| = 0.90 V on every device, Vdd fixed 1.8 V). SIMULATION ONLY.
Vdd vdd 0 1.8
Vg vg 0 0
Egp gp vdd vg 0 -1
Bdp dpref 0 V=V(vdd)-0.90
Vd_l050_w042 d_l050_w042 dpref 0
XM_l050_w042 d_l050_w042 gp vdd vdd sky130_fd_pr__pfet_01v8_lvt W=0.42 L=0.5 nf=1 mult=1
Vd_l050_w126 d_l050_w126 dpref 0
XM_l050_w126 d_l050_w126 gp vdd vdd sky130_fd_pr__pfet_01v8_lvt W=1.26 L=0.5 nf=1 mult=1
Vd_l035_w042 d_l035_w042 dpref 0
XM_l035_w042 d_l035_w042 gp vdd vdd sky130_fd_pr__pfet_01v8_lvt W=0.42 L=0.35 nf=1 mult=1

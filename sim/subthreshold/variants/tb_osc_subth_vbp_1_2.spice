* Sensitivity-grade testbench body for the osc_subth variant vbp_1_2 (circuit body only: klt sim owns .control/.end).
* SIMULATION: schematic-level netlist sim/subthreshold/variants/osc_subth_vbp_1_2.spice (issue #278 variant deck), no layout, no parasitics.
* Enable is a behavioural source that follows v(vdd), so it swings rail to rail at every swept
* supply (an explicit PULSE could not be swept with the supply in a Monte Carlo `units` request).
* It is off for 1 ns and then ramps to v(vdd) over 100 ps.
.include "osc_subth_vbp_1_2.spice"
Vdd vdd 0 1.8
Vss vss 0 0
Ben en 0 V='v(vdd)*min(max((time-1n)/100p,0),1)'
Xdut en out vdd vss osc_subth

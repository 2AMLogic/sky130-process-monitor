* DEVICE SUBTHRESHOLD PROBE (circuit body for `klt sim`; generated by gen_probe.py).
* SIMULATION ONLY. |Vgs| swept by Vg; |Vds| = 0.90 V on every device.
Vdd vdd 0 1.8
Vg vg 0 0
Egp gp vdd vg 0 -1
Bdp dpref 0 V=V(vdd)-0.90
Vd_n_w040 d_n_w040 0 0.90
XM_n_w040 d_n_w040 vg 0 0 sky130_fd_pr__nfet_01v8 W=0.4 L=0.15 nf=1 mult=1
Vd_n_w041 d_n_w041 0 0.90
XM_n_w041 d_n_w041 vg 0 0 sky130_fd_pr__nfet_01v8 W=0.41 L=0.15 nf=1 mult=1
Vd_n_w042 d_n_w042 0 0.90
XM_n_w042 d_n_w042 vg 0 0 sky130_fd_pr__nfet_01v8 W=0.42 L=0.15 nf=1 mult=1
Vd_n_w043 d_n_w043 0 0.90
XM_n_w043 d_n_w043 vg 0 0 sky130_fd_pr__nfet_01v8 W=0.43 L=0.15 nf=1 mult=1
Vd_n_w044 d_n_w044 0 0.90
XM_n_w044 d_n_w044 vg 0 0 sky130_fd_pr__nfet_01v8 W=0.44 L=0.15 nf=1 mult=1
Vd_n_w082 d_n_w082 0 0.90
XM_n_w082 d_n_w082 vg 0 0 sky130_fd_pr__nfet_01v8 W=0.82 L=0.15 nf=1 mult=1
Vd_n_w083 d_n_w083 0 0.90
XM_n_w083 d_n_w083 vg 0 0 sky130_fd_pr__nfet_01v8 W=0.83 L=0.15 nf=1 mult=1
Vd_n_w084 d_n_w084 0 0.90
XM_n_w084 d_n_w084 vg 0 0 sky130_fd_pr__nfet_01v8 W=0.84 L=0.15 nf=1 mult=1
Vd_n_w085 d_n_w085 0 0.90
XM_n_w085 d_n_w085 vg 0 0 sky130_fd_pr__nfet_01v8 W=0.85 L=0.15 nf=1 mult=1
Vd_n_w086 d_n_w086 0 0.90
XM_n_w086 d_n_w086 vg 0 0 sky130_fd_pr__nfet_01v8 W=0.86 L=0.15 nf=1 mult=1
Vd_p_w042 d_p_w042 dpref 0
XM_p_w042 d_p_w042 gp vdd vdd sky130_fd_pr__pfet_01v8 W=0.42 L=0.15 nf=1 mult=1
Vd_p_w043 d_p_w043 dpref 0
XM_p_w043 d_p_w043 gp vdd vdd sky130_fd_pr__pfet_01v8 W=0.43 L=0.15 nf=1 mult=1
Vd_p_w044 d_p_w044 dpref 0
XM_p_w044 d_p_w044 gp vdd vdd sky130_fd_pr__pfet_01v8 W=0.44 L=0.15 nf=1 mult=1
Vd_p_w082 d_p_w082 dpref 0
XM_p_w082 d_p_w082 gp vdd vdd sky130_fd_pr__pfet_01v8 W=0.82 L=0.15 nf=1 mult=1
Vd_p_w083 d_p_w083 dpref 0
XM_p_w083 d_p_w083 gp vdd vdd sky130_fd_pr__pfet_01v8 W=0.83 L=0.15 nf=1 mult=1
Vd_p_w084 d_p_w084 dpref 0
XM_p_w084 d_p_w084 gp vdd vdd sky130_fd_pr__pfet_01v8 W=0.84 L=0.15 nf=1 mult=1
Vd_p_w085 d_p_w085 dpref 0
XM_p_w085 d_p_w085 gp vdd vdd sky130_fd_pr__pfet_01v8 W=0.85 L=0.15 nf=1 mult=1
Vd_p_w086 d_p_w086 dpref 0
XM_p_w086 d_p_w086 gp vdd vdd sky130_fd_pr__pfet_01v8 W=0.86 L=0.15 nf=1 mult=1
Vd_l_w042 d_l_w042 dpref 0
XM_l_w042 d_l_w042 gp vdd vdd sky130_fd_pr__pfet_01v8_lvt W=0.42 L=0.5 nf=1 mult=1
Vd_l_w043 d_l_w043 dpref 0
XM_l_w043 d_l_w043 gp vdd vdd sky130_fd_pr__pfet_01v8_lvt W=0.43 L=0.5 nf=1 mult=1
Vd_l_w044 d_l_w044 dpref 0
XM_l_w044 d_l_w044 gp vdd vdd sky130_fd_pr__pfet_01v8_lvt W=0.44 L=0.5 nf=1 mult=1
Vd_l_w082 d_l_w082 dpref 0
XM_l_w082 d_l_w082 gp vdd vdd sky130_fd_pr__pfet_01v8_lvt W=0.82 L=0.5 nf=1 mult=1
Vd_l_w083 d_l_w083 dpref 0
XM_l_w083 d_l_w083 gp vdd vdd sky130_fd_pr__pfet_01v8_lvt W=0.83 L=0.5 nf=1 mult=1
Vd_l_w084 d_l_w084 dpref 0
XM_l_w084 d_l_w084 gp vdd vdd sky130_fd_pr__pfet_01v8_lvt W=0.84 L=0.5 nf=1 mult=1
Vd_l_w085 d_l_w085 dpref 0
XM_l_w085 d_l_w085 gp vdd vdd sky130_fd_pr__pfet_01v8_lvt W=0.85 L=0.5 nf=1 mult=1
Vd_l_w086 d_l_w086 dpref 0
XM_l_w086 d_l_w086 gp vdd vdd sky130_fd_pr__pfet_01v8_lvt W=0.86 L=0.5 nf=1 mult=1

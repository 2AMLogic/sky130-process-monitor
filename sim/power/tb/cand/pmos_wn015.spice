* EXPERIMENT VARIANT subckt for the row-7 active-power iteration (issue #280).
* Lever {"strong_w": 1.5} from the committed design point (the empty lever is the base, which
* reproduces design/osc_bank/osc_pmos.spice; asserted by gen_candidates.py).
.subckt osc_pmos_wn015 en out vdd vss
XMp1 n0 out vdd vdd sky130_fd_pr__pfet_01v8 L=0.5 W=0.42 nf=1 ad=0.1218 as=0.1218 pd=1.42 ps=1.42 nrd=0.690476190476 nrs=0.690476190476 sd=0 mult=1 m=1
XMp6 n0 en vdd vdd sky130_fd_pr__pfet_01v8 L=0.5 W=0.42 nf=1 ad=0.1218 as=0.1218 pd=1.42 ps=1.42 nrd=0.690476190476 nrs=0.690476190476 sd=0 mult=1 m=1
XMn11 n0 out mid vss sky130_fd_pr__nfet_01v8 L=0.15 W=6 nf=1 ad=1.74 as=1.74 pd=12.58 ps=12.58 nrd=0.0483333333333 nrs=0.0483333333333 sd=0 mult=1 m=1
XMn16 mid en vss vss sky130_fd_pr__nfet_01v8 L=0.15 W=6 nf=1 ad=1.74 as=1.74 pd=12.58 ps=12.58 nrd=0.0483333333333 nrs=0.0483333333333 sd=0 mult=1 m=1
XMp102 n1 n0 vdd vdd sky130_fd_pr__pfet_01v8 L=0.5 W=0.42 nf=1 ad=0.1218 as=0.1218 pd=1.42 ps=1.42 nrd=0.690476190476 nrs=0.690476190476 sd=0 mult=1 m=1
XMn112 n1 n0 vss vss sky130_fd_pr__nfet_01v8 L=0.15 W=1.5 nf=1 ad=0.435 as=0.435 pd=3.58 ps=3.58 nrd=0.193333333333 nrs=0.193333333333 sd=0 mult=1 m=1
XMp104 n2 n1 vdd vdd sky130_fd_pr__pfet_01v8 L=0.5 W=0.42 nf=1 ad=0.1218 as=0.1218 pd=1.42 ps=1.42 nrd=0.690476190476 nrs=0.690476190476 sd=0 mult=1 m=1
XMn114 n2 n1 vss vss sky130_fd_pr__nfet_01v8 L=0.15 W=1.5 nf=1 ad=0.435 as=0.435 pd=3.58 ps=3.58 nrd=0.193333333333 nrs=0.193333333333 sd=0 mult=1 m=1
XMp106 n3 n2 vdd vdd sky130_fd_pr__pfet_01v8 L=0.5 W=0.42 nf=1 ad=0.1218 as=0.1218 pd=1.42 ps=1.42 nrd=0.690476190476 nrs=0.690476190476 sd=0 mult=1 m=1
XMn116 n3 n2 vss vss sky130_fd_pr__nfet_01v8 L=0.15 W=1.5 nf=1 ad=0.435 as=0.435 pd=3.58 ps=3.58 nrd=0.193333333333 nrs=0.193333333333 sd=0 mult=1 m=1
XMp108 n4 n3 vdd vdd sky130_fd_pr__pfet_01v8 L=0.5 W=0.42 nf=1 ad=0.1218 as=0.1218 pd=1.42 ps=1.42 nrd=0.690476190476 nrs=0.690476190476 sd=0 mult=1 m=1
XMn118 n4 n3 vss vss sky130_fd_pr__nfet_01v8 L=0.15 W=1.5 nf=1 ad=0.435 as=0.435 pd=3.58 ps=3.58 nrd=0.193333333333 nrs=0.193333333333 sd=0 mult=1 m=1
XMp110 n5 n4 vdd vdd sky130_fd_pr__pfet_01v8 L=0.5 W=0.42 nf=1 ad=0.1218 as=0.1218 pd=1.42 ps=1.42 nrd=0.690476190476 nrs=0.690476190476 sd=0 mult=1 m=1
XMn120 n5 n4 vss vss sky130_fd_pr__nfet_01v8 L=0.15 W=1.5 nf=1 ad=0.435 as=0.435 pd=3.58 ps=3.58 nrd=0.193333333333 nrs=0.193333333333 sd=0 mult=1 m=1
XMp112 n6 n5 vdd vdd sky130_fd_pr__pfet_01v8 L=0.5 W=0.42 nf=1 ad=0.1218 as=0.1218 pd=1.42 ps=1.42 nrd=0.690476190476 nrs=0.690476190476 sd=0 mult=1 m=1
XMn122 n6 n5 vss vss sky130_fd_pr__nfet_01v8 L=0.15 W=1.5 nf=1 ad=0.435 as=0.435 pd=3.58 ps=3.58 nrd=0.193333333333 nrs=0.193333333333 sd=0 mult=1 m=1
XMp114 n7 n6 vdd vdd sky130_fd_pr__pfet_01v8 L=0.5 W=0.42 nf=1 ad=0.1218 as=0.1218 pd=1.42 ps=1.42 nrd=0.690476190476 nrs=0.690476190476 sd=0 mult=1 m=1
XMn124 n7 n6 vss vss sky130_fd_pr__nfet_01v8 L=0.15 W=1.5 nf=1 ad=0.435 as=0.435 pd=3.58 ps=3.58 nrd=0.193333333333 nrs=0.193333333333 sd=0 mult=1 m=1
XMp116 n8 n7 vdd vdd sky130_fd_pr__pfet_01v8 L=0.5 W=0.42 nf=1 ad=0.1218 as=0.1218 pd=1.42 ps=1.42 nrd=0.690476190476 nrs=0.690476190476 sd=0 mult=1 m=1
XMn126 n8 n7 vss vss sky130_fd_pr__nfet_01v8 L=0.15 W=1.5 nf=1 ad=0.435 as=0.435 pd=3.58 ps=3.58 nrd=0.193333333333 nrs=0.193333333333 sd=0 mult=1 m=1
XMp118 n9 n8 vdd vdd sky130_fd_pr__pfet_01v8 L=0.5 W=0.42 nf=1 ad=0.1218 as=0.1218 pd=1.42 ps=1.42 nrd=0.690476190476 nrs=0.690476190476 sd=0 mult=1 m=1
XMn128 n9 n8 vss vss sky130_fd_pr__nfet_01v8 L=0.15 W=1.5 nf=1 ad=0.435 as=0.435 pd=3.58 ps=3.58 nrd=0.193333333333 nrs=0.193333333333 sd=0 mult=1 m=1
XMp120 n10 n9 vdd vdd sky130_fd_pr__pfet_01v8 L=0.5 W=0.42 nf=1 ad=0.1218 as=0.1218 pd=1.42 ps=1.42 nrd=0.690476190476 nrs=0.690476190476 sd=0 mult=1 m=1
XMn130 n10 n9 vss vss sky130_fd_pr__nfet_01v8 L=0.15 W=1.5 nf=1 ad=0.435 as=0.435 pd=3.58 ps=3.58 nrd=0.193333333333 nrs=0.193333333333 sd=0 mult=1 m=1
XMp122 n11 n10 vdd vdd sky130_fd_pr__pfet_01v8 L=0.5 W=0.42 nf=1 ad=0.1218 as=0.1218 pd=1.42 ps=1.42 nrd=0.690476190476 nrs=0.690476190476 sd=0 mult=1 m=1
XMn132 n11 n10 vss vss sky130_fd_pr__nfet_01v8 L=0.15 W=1.5 nf=1 ad=0.435 as=0.435 pd=3.58 ps=3.58 nrd=0.193333333333 nrs=0.193333333333 sd=0 mult=1 m=1
XMp124 n12 n11 vdd vdd sky130_fd_pr__pfet_01v8 L=0.5 W=0.42 nf=1 ad=0.1218 as=0.1218 pd=1.42 ps=1.42 nrd=0.690476190476 nrs=0.690476190476 sd=0 mult=1 m=1
XMn134 n12 n11 vss vss sky130_fd_pr__nfet_01v8 L=0.15 W=1.5 nf=1 ad=0.435 as=0.435 pd=3.58 ps=3.58 nrd=0.193333333333 nrs=0.193333333333 sd=0 mult=1 m=1
XMp126 n13 n12 vdd vdd sky130_fd_pr__pfet_01v8 L=0.5 W=0.42 nf=1 ad=0.1218 as=0.1218 pd=1.42 ps=1.42 nrd=0.690476190476 nrs=0.690476190476 sd=0 mult=1 m=1
XMn136 n13 n12 vss vss sky130_fd_pr__nfet_01v8 L=0.15 W=1.5 nf=1 ad=0.435 as=0.435 pd=3.58 ps=3.58 nrd=0.193333333333 nrs=0.193333333333 sd=0 mult=1 m=1
XMp128 n14 n13 vdd vdd sky130_fd_pr__pfet_01v8 L=0.5 W=0.42 nf=1 ad=0.1218 as=0.1218 pd=1.42 ps=1.42 nrd=0.690476190476 nrs=0.690476190476 sd=0 mult=1 m=1
XMn138 n14 n13 vss vss sky130_fd_pr__nfet_01v8 L=0.15 W=1.5 nf=1 ad=0.435 as=0.435 pd=3.58 ps=3.58 nrd=0.193333333333 nrs=0.193333333333 sd=0 mult=1 m=1
XMp130 n15 n14 vdd vdd sky130_fd_pr__pfet_01v8 L=0.5 W=0.42 nf=1 ad=0.1218 as=0.1218 pd=1.42 ps=1.42 nrd=0.690476190476 nrs=0.690476190476 sd=0 mult=1 m=1
XMn140 n15 n14 vss vss sky130_fd_pr__nfet_01v8 L=0.15 W=1.5 nf=1 ad=0.435 as=0.435 pd=3.58 ps=3.58 nrd=0.193333333333 nrs=0.193333333333 sd=0 mult=1 m=1
XMp132 n16 n15 vdd vdd sky130_fd_pr__pfet_01v8 L=0.5 W=0.42 nf=1 ad=0.1218 as=0.1218 pd=1.42 ps=1.42 nrd=0.690476190476 nrs=0.690476190476 sd=0 mult=1 m=1
XMn142 n16 n15 vss vss sky130_fd_pr__nfet_01v8 L=0.15 W=1.5 nf=1 ad=0.435 as=0.435 pd=3.58 ps=3.58 nrd=0.193333333333 nrs=0.193333333333 sd=0 mult=1 m=1
XMp134 n17 n16 vdd vdd sky130_fd_pr__pfet_01v8 L=0.5 W=0.42 nf=1 ad=0.1218 as=0.1218 pd=1.42 ps=1.42 nrd=0.690476190476 nrs=0.690476190476 sd=0 mult=1 m=1
XMn144 n17 n16 vss vss sky130_fd_pr__nfet_01v8 L=0.15 W=1.5 nf=1 ad=0.435 as=0.435 pd=3.58 ps=3.58 nrd=0.193333333333 nrs=0.193333333333 sd=0 mult=1 m=1
XMp136 n18 n17 vdd vdd sky130_fd_pr__pfet_01v8 L=0.5 W=0.42 nf=1 ad=0.1218 as=0.1218 pd=1.42 ps=1.42 nrd=0.690476190476 nrs=0.690476190476 sd=0 mult=1 m=1
XMn146 n18 n17 vss vss sky130_fd_pr__nfet_01v8 L=0.15 W=1.5 nf=1 ad=0.435 as=0.435 pd=3.58 ps=3.58 nrd=0.193333333333 nrs=0.193333333333 sd=0 mult=1 m=1
XMp138 n19 n18 vdd vdd sky130_fd_pr__pfet_01v8 L=0.5 W=0.42 nf=1 ad=0.1218 as=0.1218 pd=1.42 ps=1.42 nrd=0.690476190476 nrs=0.690476190476 sd=0 mult=1 m=1
XMn148 n19 n18 vss vss sky130_fd_pr__nfet_01v8 L=0.15 W=1.5 nf=1 ad=0.435 as=0.435 pd=3.58 ps=3.58 nrd=0.193333333333 nrs=0.193333333333 sd=0 mult=1 m=1
XMp140 n20 n19 vdd vdd sky130_fd_pr__pfet_01v8 L=0.5 W=0.42 nf=1 ad=0.1218 as=0.1218 pd=1.42 ps=1.42 nrd=0.690476190476 nrs=0.690476190476 sd=0 mult=1 m=1
XMn150 n20 n19 vss vss sky130_fd_pr__nfet_01v8 L=0.15 W=1.5 nf=1 ad=0.435 as=0.435 pd=3.58 ps=3.58 nrd=0.193333333333 nrs=0.193333333333 sd=0 mult=1 m=1
XMp142 n21 n20 vdd vdd sky130_fd_pr__pfet_01v8 L=0.5 W=0.42 nf=1 ad=0.1218 as=0.1218 pd=1.42 ps=1.42 nrd=0.690476190476 nrs=0.690476190476 sd=0 mult=1 m=1
XMn152 n21 n20 vss vss sky130_fd_pr__nfet_01v8 L=0.15 W=1.5 nf=1 ad=0.435 as=0.435 pd=3.58 ps=3.58 nrd=0.193333333333 nrs=0.193333333333 sd=0 mult=1 m=1
XMp144 n22 n21 vdd vdd sky130_fd_pr__pfet_01v8 L=0.5 W=0.42 nf=1 ad=0.1218 as=0.1218 pd=1.42 ps=1.42 nrd=0.690476190476 nrs=0.690476190476 sd=0 mult=1 m=1
XMn154 n22 n21 vss vss sky130_fd_pr__nfet_01v8 L=0.15 W=1.5 nf=1 ad=0.435 as=0.435 pd=3.58 ps=3.58 nrd=0.193333333333 nrs=0.193333333333 sd=0 mult=1 m=1
XMp146 n23 n22 vdd vdd sky130_fd_pr__pfet_01v8 L=0.5 W=0.42 nf=1 ad=0.1218 as=0.1218 pd=1.42 ps=1.42 nrd=0.690476190476 nrs=0.690476190476 sd=0 mult=1 m=1
XMn156 n23 n22 vss vss sky130_fd_pr__nfet_01v8 L=0.15 W=1.5 nf=1 ad=0.435 as=0.435 pd=3.58 ps=3.58 nrd=0.193333333333 nrs=0.193333333333 sd=0 mult=1 m=1
XMp148 n24 n23 vdd vdd sky130_fd_pr__pfet_01v8 L=0.5 W=0.42 nf=1 ad=0.1218 as=0.1218 pd=1.42 ps=1.42 nrd=0.690476190476 nrs=0.690476190476 sd=0 mult=1 m=1
XMn158 n24 n23 vss vss sky130_fd_pr__nfet_01v8 L=0.15 W=1.5 nf=1 ad=0.435 as=0.435 pd=3.58 ps=3.58 nrd=0.193333333333 nrs=0.193333333333 sd=0 mult=1 m=1
XMp150 n25 n24 vdd vdd sky130_fd_pr__pfet_01v8 L=0.5 W=0.42 nf=1 ad=0.1218 as=0.1218 pd=1.42 ps=1.42 nrd=0.690476190476 nrs=0.690476190476 sd=0 mult=1 m=1
XMn160 n25 n24 vss vss sky130_fd_pr__nfet_01v8 L=0.15 W=1.5 nf=1 ad=0.435 as=0.435 pd=3.58 ps=3.58 nrd=0.193333333333 nrs=0.193333333333 sd=0 mult=1 m=1
XMp152 n26 n25 vdd vdd sky130_fd_pr__pfet_01v8 L=0.5 W=0.42 nf=1 ad=0.1218 as=0.1218 pd=1.42 ps=1.42 nrd=0.690476190476 nrs=0.690476190476 sd=0 mult=1 m=1
XMn162 n26 n25 vss vss sky130_fd_pr__nfet_01v8 L=0.15 W=1.5 nf=1 ad=0.435 as=0.435 pd=3.58 ps=3.58 nrd=0.193333333333 nrs=0.193333333333 sd=0 mult=1 m=1
XMp154 n27 n26 vdd vdd sky130_fd_pr__pfet_01v8 L=0.5 W=0.42 nf=1 ad=0.1218 as=0.1218 pd=1.42 ps=1.42 nrd=0.690476190476 nrs=0.690476190476 sd=0 mult=1 m=1
XMn164 n27 n26 vss vss sky130_fd_pr__nfet_01v8 L=0.15 W=1.5 nf=1 ad=0.435 as=0.435 pd=3.58 ps=3.58 nrd=0.193333333333 nrs=0.193333333333 sd=0 mult=1 m=1
XMp156 n28 n27 vdd vdd sky130_fd_pr__pfet_01v8 L=0.5 W=0.42 nf=1 ad=0.1218 as=0.1218 pd=1.42 ps=1.42 nrd=0.690476190476 nrs=0.690476190476 sd=0 mult=1 m=1
XMn166 n28 n27 vss vss sky130_fd_pr__nfet_01v8 L=0.15 W=1.5 nf=1 ad=0.435 as=0.435 pd=3.58 ps=3.58 nrd=0.193333333333 nrs=0.193333333333 sd=0 mult=1 m=1
XMp158 n29 n28 vdd vdd sky130_fd_pr__pfet_01v8 L=0.5 W=0.42 nf=1 ad=0.1218 as=0.1218 pd=1.42 ps=1.42 nrd=0.690476190476 nrs=0.690476190476 sd=0 mult=1 m=1
XMn168 n29 n28 vss vss sky130_fd_pr__nfet_01v8 L=0.15 W=1.5 nf=1 ad=0.435 as=0.435 pd=3.58 ps=3.58 nrd=0.193333333333 nrs=0.193333333333 sd=0 mult=1 m=1
XMp160 out n29 vdd vdd sky130_fd_pr__pfet_01v8 L=0.5 W=0.42 nf=1 ad=0.1218 as=0.1218 pd=1.42 ps=1.42 nrd=0.690476190476 nrs=0.690476190476 sd=0 mult=1 m=1
XMn170 out n29 vss vss sky130_fd_pr__nfet_01v8 L=0.15 W=1.5 nf=1 ad=0.435 as=0.435 pd=3.58 ps=3.58 nrd=0.193333333333 nrs=0.193333333333 sd=0 mult=1 m=1
.ends

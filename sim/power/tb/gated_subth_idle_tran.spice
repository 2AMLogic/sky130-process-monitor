* Power bench (IDLE, candidate, tran settle): osc_subth_gated with the enable tied to vss; supply leakage current.
* transient settle form (rshunt=1e12 kept): en held at vss from t=0; final-half mean. SIMULATION, schematic-level, candidate netlist.
.options rshunt=1e12
.include "../cand/osc_subth_gated.spice"
Vdd vdd 0 1.8
Vss vss 0 0
Ven en 0 0
Xdut en out vdd vss osc_subth_gated

* ACTIVE-power candidate bench: hd_n021 (EXPERIMENT VARIANT, not the committed design).
* Same bench shape as tb/active_osc_hd.spice; the variant subckt differs from
* design/osc_bank/osc_hd.spice by exactly the lever recorded in the iteration record.
.include "$PDK_ROOT/sky130A/libs.ref/sky130_fd_sc_hd/spice/sky130_fd_sc_hd.spice"
.include "cand/hd_n021.spice"
Vdd vdd 0 1.8
Vss vss 0 0
Ben en 0 V='v(vdd)*min(max((time-1n)/100p,0),1)'
Xdut en out vdd vss osc_hd_n021

* Power bench (IDLE, settle): osc_wire with the enable held at vss for the whole window; transient
* from t=0 (caps at 0, a defined powered-up-gated-off state); mean supply current over the final
* half-window (request .meas). Replaces the op-form idle bench, whose DC solve on the gated-off
* ring is non-unique (issue #279; records/2026-11-21-idle-settle.md). SIMULATION, schematic-level.
* Sensitivity-grade testbench body for osc_wire (circuit body only: klt sim owns .control/.end).
* SIMULATION: schematic-level netlist design/osc_bank/osc_wire.spice, no layout, no parasitics.
* Enable is a behavioural source that follows v(vdd), so it swings rail to rail at every swept
* supply (an explicit PULSE could not be swept with the supply in a Monte Carlo `units` request).
* It is off for 1 ns and then ramps to v(vdd) over 100 ps.
.options rshunt=1e14
.include "../../../design/osc_bank/osc_wire.spice"
Vdd vdd 0 1.8
Vss vss 0 0
Ven en 0 0
Xdut en out vdd vss osc_wire

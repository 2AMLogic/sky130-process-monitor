* extracted by klt extract --deck sky130

* cell osc_subth
* pin en
* pin out
* pin vbp
* pin vdd
* pin vss
.SUBCKT osc_subth en out vbp vdd vss
* device instance $1 r0 *1 5.245,0.81 nfet
M$1 \$4 \$3 vss vss nfet L=0.15U W=0.42U AS=0.294P AD=0.1218P PS=2.24U PD=1.42U
* device instance $2 r0 *1 8.775,0.81 nfet
M$2 \$5 \$4 vss vss nfet L=0.15U W=0.42U AS=0.294P AD=0.1218P PS=2.24U PD=1.42U
* device instance $3 r0 *1 12.305,0.81 nfet
M$3 \$6 \$5 vss vss nfet L=0.15U W=0.42U AS=0.294P AD=0.1218P PS=2.24U PD=1.42U
* device instance $4 r0 *1 15.835,0.81 nfet
M$4 \$7 \$6 vss vss nfet L=0.15U W=0.42U AS=0.294P AD=0.1218P PS=2.24U PD=1.42U
* device instance $5 r0 *1 19.365,0.81 nfet
M$5 \$8 \$7 vss vss nfet L=0.15U W=0.42U AS=0.294P AD=0.1218P PS=2.24U PD=1.42U
* device instance $6 r0 *1 22.895,0.81 nfet
M$6 \$9 \$8 vss vss nfet L=0.15U W=0.42U AS=0.294P AD=0.1218P PS=2.24U PD=1.42U
* device instance $7 r0 *1 26.425,0.81 nfet
M$7 \$10 \$9 vss vss nfet L=0.15U W=0.42U AS=0.294P AD=0.1218P PS=2.24U PD=1.42U
* device instance $8 r0 *1 29.955,0.81 nfet
M$8 \$11 \$10 vss vss nfet L=0.15U W=0.42U AS=0.294P AD=0.1218P PS=2.24U
+ PD=1.42U
* device instance $9 r0 *1 33.485,0.81 nfet
M$9 \$12 \$11 vss vss nfet L=0.15U W=0.42U AS=0.294P AD=0.1218P PS=2.24U
+ PD=1.42U
* device instance $10 r0 *1 37.015,0.81 nfet
M$10 \$13 \$12 vss vss nfet L=0.15U W=0.42U AS=0.294P AD=0.1218P PS=2.24U
+ PD=1.42U
* device instance $11 r0 *1 40.545,0.81 nfet
M$11 \$14 \$13 vss vss nfet L=0.15U W=0.42U AS=0.294P AD=0.1218P PS=2.24U
+ PD=1.42U
* device instance $12 r0 *1 44.075,0.81 nfet
M$12 \$15 \$14 vss vss nfet L=0.15U W=0.42U AS=0.294P AD=0.1218P PS=2.24U
+ PD=1.42U
* device instance $13 r0 *1 47.605,0.81 nfet
M$13 \$16 \$15 vss vss nfet L=0.15U W=0.42U AS=0.294P AD=0.1218P PS=2.24U
+ PD=1.42U
* device instance $14 r0 *1 51.135,0.81 nfet
M$14 out \$16 vss vss nfet L=0.15U W=0.42U AS=0.294P AD=0.1218P PS=2.24U
+ PD=1.42U
* device instance $15 r0 *1 0.865,1.02 nfet
M$15 \$17 en vss vss nfet L=0.15U W=0.84U AS=0.2436P AD=0.294P PS=2.26U PD=1.54U
* device instance $16 r0 *1 1.715,1.02 nfet
M$16 \$3 out \$17 vss nfet L=0.15U W=0.84U AS=0.294P AD=0.2436P PS=1.54U
+ PD=2.26U
* device instance $17 r0 *1 0.865,3.76 pfet
M$17 \$3 en vdd vdd pfet L=0.15U W=0.84U AS=0.2436P AD=0.294P PS=2.26U PD=1.54U
* device instance $18 r0 *1 1.715,3.76 pfet
M$18 vdd out \$3 vdd pfet L=0.15U W=0.84U AS=0.294P AD=0.2436P PS=1.54U PD=2.26U
* device instance $19 r0 *1 4.22,3.97 pfet
M$19 vdd vbp \$21 vdd pfet L=0.5U W=0.42U AS=0.2205P AD=0.1218P PS=1.54U
+ PD=1.42U
* device instance $20 r0 *1 5.245,3.76 pfet
M$20 \$4 \$3 \$21 vdd pfet L=0.15U W=0.84U AS=0.2205P AD=0.2436P PS=1.54U
+ PD=2.26U
* device instance $21 r0 *1 7.75,3.97 pfet
M$21 vdd vbp \$22 vdd pfet L=0.5U W=0.42U AS=0.2205P AD=0.1218P PS=1.54U
+ PD=1.42U
* device instance $22 r0 *1 8.775,3.76 pfet
M$22 \$5 \$4 \$22 vdd pfet L=0.15U W=0.84U AS=0.2205P AD=0.2436P PS=1.54U
+ PD=2.26U
* device instance $23 r0 *1 11.28,3.97 pfet
M$23 vdd vbp \$23 vdd pfet L=0.5U W=0.42U AS=0.2205P AD=0.1218P PS=1.54U
+ PD=1.42U
* device instance $24 r0 *1 12.305,3.76 pfet
M$24 \$6 \$5 \$23 vdd pfet L=0.15U W=0.84U AS=0.2205P AD=0.2436P PS=1.54U
+ PD=2.26U
* device instance $25 r0 *1 14.81,3.97 pfet
M$25 vdd vbp \$24 vdd pfet L=0.5U W=0.42U AS=0.2205P AD=0.1218P PS=1.54U
+ PD=1.42U
* device instance $26 r0 *1 15.835,3.76 pfet
M$26 \$7 \$6 \$24 vdd pfet L=0.15U W=0.84U AS=0.2205P AD=0.2436P PS=1.54U
+ PD=2.26U
* device instance $27 r0 *1 18.34,3.97 pfet
M$27 vdd vbp \$25 vdd pfet L=0.5U W=0.42U AS=0.2205P AD=0.1218P PS=1.54U
+ PD=1.42U
* device instance $28 r0 *1 19.365,3.76 pfet
M$28 \$8 \$7 \$25 vdd pfet L=0.15U W=0.84U AS=0.2205P AD=0.2436P PS=1.54U
+ PD=2.26U
* device instance $29 r0 *1 21.87,3.97 pfet
M$29 vdd vbp \$26 vdd pfet L=0.5U W=0.42U AS=0.2205P AD=0.1218P PS=1.54U
+ PD=1.42U
* device instance $30 r0 *1 22.895,3.76 pfet
M$30 \$9 \$8 \$26 vdd pfet L=0.15U W=0.84U AS=0.2205P AD=0.2436P PS=1.54U
+ PD=2.26U
* device instance $31 r0 *1 25.4,3.97 pfet
M$31 vdd vbp \$27 vdd pfet L=0.5U W=0.42U AS=0.2205P AD=0.1218P PS=1.54U
+ PD=1.42U
* device instance $32 r0 *1 26.425,3.76 pfet
M$32 \$10 \$9 \$27 vdd pfet L=0.15U W=0.84U AS=0.2205P AD=0.2436P PS=1.54U
+ PD=2.26U
* device instance $33 r0 *1 28.93,3.97 pfet
M$33 vdd vbp \$28 vdd pfet L=0.5U W=0.42U AS=0.2205P AD=0.1218P PS=1.54U
+ PD=1.42U
* device instance $34 r0 *1 29.955,3.76 pfet
M$34 \$11 \$10 \$28 vdd pfet L=0.15U W=0.84U AS=0.2205P AD=0.2436P PS=1.54U
+ PD=2.26U
* device instance $35 r0 *1 32.46,3.97 pfet
M$35 vdd vbp \$29 vdd pfet L=0.5U W=0.42U AS=0.2205P AD=0.1218P PS=1.54U
+ PD=1.42U
* device instance $36 r0 *1 33.485,3.76 pfet
M$36 \$12 \$11 \$29 vdd pfet L=0.15U W=0.84U AS=0.2205P AD=0.2436P PS=1.54U
+ PD=2.26U
* device instance $37 r0 *1 35.99,3.97 pfet
M$37 vdd vbp \$30 vdd pfet L=0.5U W=0.42U AS=0.2205P AD=0.1218P PS=1.54U
+ PD=1.42U
* device instance $38 r0 *1 37.015,3.76 pfet
M$38 \$13 \$12 \$30 vdd pfet L=0.15U W=0.84U AS=0.2205P AD=0.2436P PS=1.54U
+ PD=2.26U
* device instance $39 r0 *1 39.52,3.97 pfet
M$39 vdd vbp \$31 vdd pfet L=0.5U W=0.42U AS=0.2205P AD=0.1218P PS=1.54U
+ PD=1.42U
* device instance $40 r0 *1 40.545,3.76 pfet
M$40 \$14 \$13 \$31 vdd pfet L=0.15U W=0.84U AS=0.2205P AD=0.2436P PS=1.54U
+ PD=2.26U
* device instance $41 r0 *1 43.05,3.97 pfet
M$41 vdd vbp \$32 vdd pfet L=0.5U W=0.42U AS=0.2205P AD=0.1218P PS=1.54U
+ PD=1.42U
* device instance $42 r0 *1 44.075,3.76 pfet
M$42 \$15 \$14 \$32 vdd pfet L=0.15U W=0.84U AS=0.2205P AD=0.2436P PS=1.54U
+ PD=2.26U
* device instance $43 r0 *1 46.58,3.97 pfet
M$43 vdd vbp \$33 vdd pfet L=0.5U W=0.42U AS=0.2205P AD=0.1218P PS=1.54U
+ PD=1.42U
* device instance $44 r0 *1 47.605,3.76 pfet
M$44 \$16 \$15 \$33 vdd pfet L=0.15U W=0.84U AS=0.2205P AD=0.2436P PS=1.54U
+ PD=2.26U
* device instance $45 r0 *1 50.11,3.97 pfet
M$45 vdd vbp \$34 vdd pfet L=0.5U W=0.42U AS=0.2205P AD=0.1218P PS=1.54U
+ PD=1.42U
* device instance $46 r0 *1 51.135,3.76 pfet
M$46 out \$16 \$34 vdd pfet L=0.15U W=0.84U AS=0.2205P AD=0.2436P PS=1.54U
+ PD=2.26U
* device instance $47 r0 *1 75.627,10.9 res_high_po
X$47 vss vbp vss res_high_po r=1263179.60497 L=1359.92U W=0.35U
* device instance $48 r0 *1 72.515,24.4 res_high_po
X$48 vbp vdd vss res_high_po r=251639.724822 L=269.99U W=0.35U
.ENDS osc_subth

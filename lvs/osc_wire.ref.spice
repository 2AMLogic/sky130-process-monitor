.subckt osc_wire en out vdd vss
XMp1 s0 s30 vdd vdd sky130_fd_pr__pfet_01v8 L=0.15 W=8.0 nf=1 ad=2.32 as=2.32 pd=16.58 ps=16.58 nrd=0.03625 nrs=0.03625 sa=0 sb=0 sd=0 mult=1 m=1
XMp6 s0 en vdd vdd sky130_fd_pr__pfet_01v8 L=0.15 W=8.0 nf=1 ad=2.32 as=2.32 pd=16.58 ps=16.58 nrd=0.03625 nrs=0.03625 sa=0 sb=0 sd=0 mult=1 m=1
XMn11 s0 s30 mid vss sky130_fd_pr__nfet_01v8 L=0.15 W=8.0 nf=1 ad=2.32 as=2.32 pd=16.58 ps=16.58 nrd=0.03625 nrs=0.03625 sa=0 sb=0 sd=0 mult=1 m=1
XMn16 mid en vss vss sky130_fd_pr__nfet_01v8 L=0.15 W=8.0 nf=1 ad=2.32 as=2.32 pd=16.58 ps=16.58 nrd=0.03625 nrs=0.03625 sa=0 sb=0 sd=0 mult=1 m=1
XMp27 s1 s0 vdd vdd sky130_fd_pr__pfet_01v8 L=0.15 W=8.0 nf=1 ad=2.32 as=2.32 pd=16.58 ps=16.58 nrd=0.03625 nrs=0.03625 sa=0 sb=0 sd=0 mult=1 m=1
XMn32 s1 s0 vss vss sky130_fd_pr__nfet_01v8 L=0.15 W=4.0 nf=1 ad=1.16 as=1.16 pd=8.58 ps=8.58 nrd=0.0725 nrs=0.0725 sa=0 sb=0 sd=0 mult=1 m=1
XMp43 s2 s1 vdd vdd sky130_fd_pr__pfet_01v8 L=0.15 W=8.0 nf=1 ad=2.32 as=2.32 pd=16.58 ps=16.58 nrd=0.03625 nrs=0.03625 sa=0 sb=0 sd=0 mult=1 m=1
XMn48 s2 s1 vss vss sky130_fd_pr__nfet_01v8 L=0.15 W=4.0 nf=1 ad=1.16 as=1.16 pd=8.58 ps=8.58 nrd=0.0725 nrs=0.0725 sa=0 sb=0 sd=0 mult=1 m=1
XMp59 s3 s2 vdd vdd sky130_fd_pr__pfet_01v8 L=0.15 W=8.0 nf=1 ad=2.32 as=2.32 pd=16.58 ps=16.58 nrd=0.03625 nrs=0.03625 sa=0 sb=0 sd=0 mult=1 m=1
XMn64 s3 s2 vss vss sky130_fd_pr__nfet_01v8 L=0.15 W=4.0 nf=1 ad=1.16 as=1.16 pd=8.58 ps=8.58 nrd=0.0725 nrs=0.0725 sa=0 sb=0 sd=0 mult=1 m=1
XMp75 s4 s3 vdd vdd sky130_fd_pr__pfet_01v8 L=0.15 W=8.0 nf=1 ad=2.32 as=2.32 pd=16.58 ps=16.58 nrd=0.03625 nrs=0.03625 sa=0 sb=0 sd=0 mult=1 m=1
XMn80 s4 s3 vss vss sky130_fd_pr__nfet_01v8 L=0.15 W=4.0 nf=1 ad=1.16 as=1.16 pd=8.58 ps=8.58 nrd=0.0725 nrs=0.0725 sa=0 sb=0 sd=0 mult=1 m=1
XMp91 s5 s4 vdd vdd sky130_fd_pr__pfet_01v8 L=0.15 W=8.0 nf=1 ad=2.32 as=2.32 pd=16.58 ps=16.58 nrd=0.03625 nrs=0.03625 sa=0 sb=0 sd=0 mult=1 m=1
XMn96 s5 s4 vss vss sky130_fd_pr__nfet_01v8 L=0.15 W=4.0 nf=1 ad=1.16 as=1.16 pd=8.58 ps=8.58 nrd=0.0725 nrs=0.0725 sa=0 sb=0 sd=0 mult=1 m=1
XMp107 s6 s5 vdd vdd sky130_fd_pr__pfet_01v8 L=0.15 W=8.0 nf=1 ad=2.32 as=2.32 pd=16.58 ps=16.58 nrd=0.03625 nrs=0.03625 sa=0 sb=0 sd=0 mult=1 m=1
XMn112 s6 s5 vss vss sky130_fd_pr__nfet_01v8 L=0.15 W=4.0 nf=1 ad=1.16 as=1.16 pd=8.58 ps=8.58 nrd=0.0725 nrs=0.0725 sa=0 sb=0 sd=0 mult=1 m=1
XMp123 s7 s6 vdd vdd sky130_fd_pr__pfet_01v8 L=0.15 W=8.0 nf=1 ad=2.32 as=2.32 pd=16.58 ps=16.58 nrd=0.03625 nrs=0.03625 sa=0 sb=0 sd=0 mult=1 m=1
XMn128 s7 s6 vss vss sky130_fd_pr__nfet_01v8 L=0.15 W=4.0 nf=1 ad=1.16 as=1.16 pd=8.58 ps=8.58 nrd=0.0725 nrs=0.0725 sa=0 sb=0 sd=0 mult=1 m=1
XMp139 s8 s7 vdd vdd sky130_fd_pr__pfet_01v8 L=0.15 W=8.0 nf=1 ad=2.32 as=2.32 pd=16.58 ps=16.58 nrd=0.03625 nrs=0.03625 sa=0 sb=0 sd=0 mult=1 m=1
XMn144 s8 s7 vss vss sky130_fd_pr__nfet_01v8 L=0.15 W=4.0 nf=1 ad=1.16 as=1.16 pd=8.58 ps=8.58 nrd=0.0725 nrs=0.0725 sa=0 sb=0 sd=0 mult=1 m=1
XMp155 s9 s8 vdd vdd sky130_fd_pr__pfet_01v8 L=0.15 W=8.0 nf=1 ad=2.32 as=2.32 pd=16.58 ps=16.58 nrd=0.03625 nrs=0.03625 sa=0 sb=0 sd=0 mult=1 m=1
XMn160 s9 s8 vss vss sky130_fd_pr__nfet_01v8 L=0.15 W=4.0 nf=1 ad=1.16 as=1.16 pd=8.58 ps=8.58 nrd=0.0725 nrs=0.0725 sa=0 sb=0 sd=0 mult=1 m=1
XMp171 s10 s9 vdd vdd sky130_fd_pr__pfet_01v8 L=0.15 W=8.0 nf=1 ad=2.32 as=2.32 pd=16.58 ps=16.58 nrd=0.03625 nrs=0.03625 sa=0 sb=0 sd=0 mult=1 m=1
XMn176 s10 s9 vss vss sky130_fd_pr__nfet_01v8 L=0.15 W=4.0 nf=1 ad=1.16 as=1.16 pd=8.58 ps=8.58 nrd=0.0725 nrs=0.0725 sa=0 sb=0 sd=0 mult=1 m=1
XMp187 s11 s10 vdd vdd sky130_fd_pr__pfet_01v8 L=0.15 W=8.0 nf=1 ad=2.32 as=2.32 pd=16.58 ps=16.58 nrd=0.03625 nrs=0.03625 sa=0 sb=0 sd=0 mult=1 m=1
XMn192 s11 s10 vss vss sky130_fd_pr__nfet_01v8 L=0.15 W=4.0 nf=1 ad=1.16 as=1.16 pd=8.58 ps=8.58 nrd=0.0725 nrs=0.0725 sa=0 sb=0 sd=0 mult=1 m=1
XMp203 s12 s11 vdd vdd sky130_fd_pr__pfet_01v8 L=0.15 W=8.0 nf=1 ad=2.32 as=2.32 pd=16.58 ps=16.58 nrd=0.03625 nrs=0.03625 sa=0 sb=0 sd=0 mult=1 m=1
XMn208 s12 s11 vss vss sky130_fd_pr__nfet_01v8 L=0.15 W=4.0 nf=1 ad=1.16 as=1.16 pd=8.58 ps=8.58 nrd=0.0725 nrs=0.0725 sa=0 sb=0 sd=0 mult=1 m=1
XMp219 s13 s12 vdd vdd sky130_fd_pr__pfet_01v8 L=0.15 W=8.0 nf=1 ad=2.32 as=2.32 pd=16.58 ps=16.58 nrd=0.03625 nrs=0.03625 sa=0 sb=0 sd=0 mult=1 m=1
XMn224 s13 s12 vss vss sky130_fd_pr__nfet_01v8 L=0.15 W=4.0 nf=1 ad=1.16 as=1.16 pd=8.58 ps=8.58 nrd=0.0725 nrs=0.0725 sa=0 sb=0 sd=0 mult=1 m=1
XMp235 s14 s13 vdd vdd sky130_fd_pr__pfet_01v8 L=0.15 W=8.0 nf=1 ad=2.32 as=2.32 pd=16.58 ps=16.58 nrd=0.03625 nrs=0.03625 sa=0 sb=0 sd=0 mult=1 m=1
XMn240 s14 s13 vss vss sky130_fd_pr__nfet_01v8 L=0.15 W=4.0 nf=1 ad=1.16 as=1.16 pd=8.58 ps=8.58 nrd=0.0725 nrs=0.0725 sa=0 sb=0 sd=0 mult=1 m=1
XMp251 s15 s14 vdd vdd sky130_fd_pr__pfet_01v8 L=0.15 W=8.0 nf=1 ad=2.32 as=2.32 pd=16.58 ps=16.58 nrd=0.03625 nrs=0.03625 sa=0 sb=0 sd=0 mult=1 m=1
XMn256 s15 s14 vss vss sky130_fd_pr__nfet_01v8 L=0.15 W=4.0 nf=1 ad=1.16 as=1.16 pd=8.58 ps=8.58 nrd=0.0725 nrs=0.0725 sa=0 sb=0 sd=0 mult=1 m=1
XMp267 s16 s15 vdd vdd sky130_fd_pr__pfet_01v8 L=0.15 W=8.0 nf=1 ad=2.32 as=2.32 pd=16.58 ps=16.58 nrd=0.03625 nrs=0.03625 sa=0 sb=0 sd=0 mult=1 m=1
XMn272 s16 s15 vss vss sky130_fd_pr__nfet_01v8 L=0.15 W=4.0 nf=1 ad=1.16 as=1.16 pd=8.58 ps=8.58 nrd=0.0725 nrs=0.0725 sa=0 sb=0 sd=0 mult=1 m=1
XMp283 s17 s16 vdd vdd sky130_fd_pr__pfet_01v8 L=0.15 W=8.0 nf=1 ad=2.32 as=2.32 pd=16.58 ps=16.58 nrd=0.03625 nrs=0.03625 sa=0 sb=0 sd=0 mult=1 m=1
XMn288 s17 s16 vss vss sky130_fd_pr__nfet_01v8 L=0.15 W=4.0 nf=1 ad=1.16 as=1.16 pd=8.58 ps=8.58 nrd=0.0725 nrs=0.0725 sa=0 sb=0 sd=0 mult=1 m=1
XMp299 s18 s17 vdd vdd sky130_fd_pr__pfet_01v8 L=0.15 W=8.0 nf=1 ad=2.32 as=2.32 pd=16.58 ps=16.58 nrd=0.03625 nrs=0.03625 sa=0 sb=0 sd=0 mult=1 m=1
XMn304 s18 s17 vss vss sky130_fd_pr__nfet_01v8 L=0.15 W=4.0 nf=1 ad=1.16 as=1.16 pd=8.58 ps=8.58 nrd=0.0725 nrs=0.0725 sa=0 sb=0 sd=0 mult=1 m=1
XMp315 s19 s18 vdd vdd sky130_fd_pr__pfet_01v8 L=0.15 W=8.0 nf=1 ad=2.32 as=2.32 pd=16.58 ps=16.58 nrd=0.03625 nrs=0.03625 sa=0 sb=0 sd=0 mult=1 m=1
XMn320 s19 s18 vss vss sky130_fd_pr__nfet_01v8 L=0.15 W=4.0 nf=1 ad=1.16 as=1.16 pd=8.58 ps=8.58 nrd=0.0725 nrs=0.0725 sa=0 sb=0 sd=0 mult=1 m=1
XMp331 s20 s19 vdd vdd sky130_fd_pr__pfet_01v8 L=0.15 W=8.0 nf=1 ad=2.32 as=2.32 pd=16.58 ps=16.58 nrd=0.03625 nrs=0.03625 sa=0 sb=0 sd=0 mult=1 m=1
XMn336 s20 s19 vss vss sky130_fd_pr__nfet_01v8 L=0.15 W=4.0 nf=1 ad=1.16 as=1.16 pd=8.58 ps=8.58 nrd=0.0725 nrs=0.0725 sa=0 sb=0 sd=0 mult=1 m=1
XMp347 s21 s20 vdd vdd sky130_fd_pr__pfet_01v8 L=0.15 W=8.0 nf=1 ad=2.32 as=2.32 pd=16.58 ps=16.58 nrd=0.03625 nrs=0.03625 sa=0 sb=0 sd=0 mult=1 m=1
XMn352 s21 s20 vss vss sky130_fd_pr__nfet_01v8 L=0.15 W=4.0 nf=1 ad=1.16 as=1.16 pd=8.58 ps=8.58 nrd=0.0725 nrs=0.0725 sa=0 sb=0 sd=0 mult=1 m=1
XMp363 s22 s21 vdd vdd sky130_fd_pr__pfet_01v8 L=0.15 W=8.0 nf=1 ad=2.32 as=2.32 pd=16.58 ps=16.58 nrd=0.03625 nrs=0.03625 sa=0 sb=0 sd=0 mult=1 m=1
XMn368 s22 s21 vss vss sky130_fd_pr__nfet_01v8 L=0.15 W=4.0 nf=1 ad=1.16 as=1.16 pd=8.58 ps=8.58 nrd=0.0725 nrs=0.0725 sa=0 sb=0 sd=0 mult=1 m=1
XMp379 s23 s22 vdd vdd sky130_fd_pr__pfet_01v8 L=0.15 W=8.0 nf=1 ad=2.32 as=2.32 pd=16.58 ps=16.58 nrd=0.03625 nrs=0.03625 sa=0 sb=0 sd=0 mult=1 m=1
XMn384 s23 s22 vss vss sky130_fd_pr__nfet_01v8 L=0.15 W=4.0 nf=1 ad=1.16 as=1.16 pd=8.58 ps=8.58 nrd=0.0725 nrs=0.0725 sa=0 sb=0 sd=0 mult=1 m=1
XMp395 s24 s23 vdd vdd sky130_fd_pr__pfet_01v8 L=0.15 W=8.0 nf=1 ad=2.32 as=2.32 pd=16.58 ps=16.58 nrd=0.03625 nrs=0.03625 sa=0 sb=0 sd=0 mult=1 m=1
XMn400 s24 s23 vss vss sky130_fd_pr__nfet_01v8 L=0.15 W=4.0 nf=1 ad=1.16 as=1.16 pd=8.58 ps=8.58 nrd=0.0725 nrs=0.0725 sa=0 sb=0 sd=0 mult=1 m=1
XMp411 s25 s24 vdd vdd sky130_fd_pr__pfet_01v8 L=0.15 W=8.0 nf=1 ad=2.32 as=2.32 pd=16.58 ps=16.58 nrd=0.03625 nrs=0.03625 sa=0 sb=0 sd=0 mult=1 m=1
XMn416 s25 s24 vss vss sky130_fd_pr__nfet_01v8 L=0.15 W=4.0 nf=1 ad=1.16 as=1.16 pd=8.58 ps=8.58 nrd=0.0725 nrs=0.0725 sa=0 sb=0 sd=0 mult=1 m=1
XMp427 s26 s25 vdd vdd sky130_fd_pr__pfet_01v8 L=0.15 W=8.0 nf=1 ad=2.32 as=2.32 pd=16.58 ps=16.58 nrd=0.03625 nrs=0.03625 sa=0 sb=0 sd=0 mult=1 m=1
XMn432 s26 s25 vss vss sky130_fd_pr__nfet_01v8 L=0.15 W=4.0 nf=1 ad=1.16 as=1.16 pd=8.58 ps=8.58 nrd=0.0725 nrs=0.0725 sa=0 sb=0 sd=0 mult=1 m=1
XMp443 s27 s26 vdd vdd sky130_fd_pr__pfet_01v8 L=0.15 W=8.0 nf=1 ad=2.32 as=2.32 pd=16.58 ps=16.58 nrd=0.03625 nrs=0.03625 sa=0 sb=0 sd=0 mult=1 m=1
XMn448 s27 s26 vss vss sky130_fd_pr__nfet_01v8 L=0.15 W=4.0 nf=1 ad=1.16 as=1.16 pd=8.58 ps=8.58 nrd=0.0725 nrs=0.0725 sa=0 sb=0 sd=0 mult=1 m=1
XMp459 s28 s27 vdd vdd sky130_fd_pr__pfet_01v8 L=0.15 W=8.0 nf=1 ad=2.32 as=2.32 pd=16.58 ps=16.58 nrd=0.03625 nrs=0.03625 sa=0 sb=0 sd=0 mult=1 m=1
XMn464 s28 s27 vss vss sky130_fd_pr__nfet_01v8 L=0.15 W=4.0 nf=1 ad=1.16 as=1.16 pd=8.58 ps=8.58 nrd=0.0725 nrs=0.0725 sa=0 sb=0 sd=0 mult=1 m=1
XMp475 s29 s28 vdd vdd sky130_fd_pr__pfet_01v8 L=0.15 W=8.0 nf=1 ad=2.32 as=2.32 pd=16.58 ps=16.58 nrd=0.03625 nrs=0.03625 sa=0 sb=0 sd=0 mult=1 m=1
XMn480 s29 s28 vss vss sky130_fd_pr__nfet_01v8 L=0.15 W=4.0 nf=1 ad=1.16 as=1.16 pd=8.58 ps=8.58 nrd=0.0725 nrs=0.0725 sa=0 sb=0 sd=0 mult=1 m=1
XMp491 s30 s29 vdd vdd sky130_fd_pr__pfet_01v8 L=0.15 W=8.0 nf=1 ad=2.32 as=2.32 pd=16.58 ps=16.58 nrd=0.03625 nrs=0.03625 sa=0 sb=0 sd=0 mult=1 m=1
XMn496 s30 s29 vss vss sky130_fd_pr__nfet_01v8 L=0.15 W=4.0 nf=1 ad=1.16 as=1.16 pd=8.58 ps=8.58 nrd=0.0725 nrs=0.0725 sa=0 sb=0 sd=0 mult=1 m=1
.ends

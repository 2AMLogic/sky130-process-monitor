* extracted by klt extract --deck sky130

* cell readout
* pin VDD
* pin VSS
* pin _0000_
* pin _0001_
* pin _0002_
* pin _0003_
* pin _0004_
* pin _0005_
* pin _0006_
* pin _0007_
* pin _0008_
* pin _0009_
* pin _0010_
* pin _0011_
* pin _0012_
* pin _0013_
* pin _0014_
* pin _0015_
* pin _0016_
* pin _0017_
* pin _0018_
* pin _0019_
* pin _0020_
* pin _0021_
* pin _0022_
* pin _0023_
* pin _0024_
* pin _0025_
* pin _0026_
* pin _0027_
* pin _0028_
* pin _0029_
* pin _0030_
* pin _0031_
* pin _0032_
* pin _0033_
* pin _0034_
* pin _0035_
* pin _0036_
* pin _0037_
* pin _0038_
* pin _0039_
* pin _0040_
* pin _0041_
* pin _0042_
* pin _0043_
* pin _0044_
* pin _0045_
* pin _0046_
* pin _0047_
* pin _0048_
* pin _0049_
* pin _0050_
* pin _0051_
* pin _0052_
* pin _0053_
* pin _0054_
* pin _0055_
* pin _0056_
* pin _0057_
* pin _0058_
* pin _0059_
* pin _0060_
* pin _0061_
* pin _0062_
* pin _0063_
* pin _0064_
* pin _0065_
* pin _0066_
* pin _0067_
* pin _0068_
* pin _0069_
* pin _0070_
* pin _0071_
* pin _0072_
* pin _0073_
* pin _0074_
* pin _0075_
* pin _0076_
* pin _0077_
* pin _0078_
* pin _0079_
* pin _0080_
* pin _0081_
* pin _0082_
* pin _0083_
* pin _0084_
* pin _0085_
* pin _0086_
* pin _0087_
* pin _0088_
* pin _0089_
* pin _0090_
* pin _0091_
* pin _0092_
* pin _0093_
* pin _0094_
* pin _0095_
* pin _0096_
* pin _0097_
* pin _0098_
* pin _0099_
* pin _0100_
* pin _0101_
* pin _0102_
* pin _0103_
* pin _0104_
* pin _0105_
* pin _0106_
* pin _0107_
* pin _0108_
* pin _0109_
* pin _0110_
* pin _0111_
* pin _0112_
* pin _0113_
* pin _0114_
* pin _0115_
* pin _0116_
* pin _0117_
* pin _0118_
* pin _0119_
* pin _0120_
* pin _0121_
* pin _0122_
* pin _0123_
* pin _0124_
* pin _0125_
* pin _0126_
* pin _0127_
* pin _0128_
* pin _0129_
* pin _0130_
* pin _0131_
* pin _0132_
* pin _0133_
* pin _0134_
* pin _0135_
* pin _0136_
* pin _0137_
* pin _0138_
* pin _0139_
* pin _0140_
* pin _0141_
* pin _0142_
* pin _0143_
* pin _0144_
* pin _0145_
* pin _0146_
* pin _0147_
* pin _0148_
* pin _0149_
* pin _0150_
* pin _0151_
* pin _0152_
* pin _0153_
* pin _0154_
* pin _0155_
* pin _0156_
* pin _0157_
* pin _0158_
* pin _0159_
* pin _0160_
* pin _0161_
* pin _0162_
* pin _0163_
* pin _0164_
* pin _0165_
* pin _0166_
* pin _0167_
* pin _0168_
* pin _0169_
* pin _0170_
* pin _0171_
* pin _0172_
* pin _0173_
* pin _0174_
* pin _0175_
* pin _0176_
* pin _0177_
* pin _0178_
* pin _0179_
* pin _0180_
* pin _0181_
* pin _0182_
* pin _0183_
* pin _0184_
* pin _0185_
* pin _0186_
* pin _0187_
* pin _0188_
* pin _0189_
* pin _0190_
* pin _0191_
* pin _0192_
* pin _0193_
* pin _0194_
* pin _0195_
* pin _0196_
* pin _0197_
* pin _0198_
* pin _0199_
* pin _0200_
* pin _0201_
* pin _0202_
* pin _0203_
* pin _0204_
* pin _0205_
* pin _0206_
* pin _0207_
* pin _0208_
* pin _0209_
* pin _0210_
* pin _0211_
* pin _0212_
* pin _0213_
* pin _0214_
* pin _0215_
* pin _0216_
* pin _0217_
* pin _0218_
* pin _0219_
* pin _0220_
* pin _0221_
* pin _0222_
* pin _0223_
* pin _0224_
* pin _0225_
* pin _0226_
* pin _0227_
* pin _0228_
* pin _0229_
* pin _0230_
* pin _0231_
* pin _0232_
* pin _0233_
* pin _0234_
* pin _0235_
* pin _0236_
* pin _0237_
* pin _0238_
* pin _0239_
* pin _0240_
* pin _0241_
* pin _0242_
* pin _0243_
* pin _0244_
* pin _0245_
* pin _0246_
* pin _0247_
* pin _0248_
* pin _0249_
* pin _0250_
* pin _0251_
* pin _0252_
* pin _0253_
* pin _0254_
* pin _0255_
* pin _0256_
* pin _0257_
* pin _0258_
* pin _0259_
* pin _0260_
* pin _0261_
* pin _0262_
* pin _0263_
* pin _0264_
* pin _0265_
* pin _0266_
* pin _0267_
* pin _0268_
* pin _0269_
* pin _0270_
* pin _0271_
* pin _0272_
* pin _0273_
* pin _0274_
* pin _0275_
* pin _0276_
* pin _0277_
* pin _0278_
* pin _0279_
* pin _0280_
* pin _0281_
* pin _0282_
* pin _0283_
* pin _0284_
* pin _0285_
* pin _0286_
* pin _0287_
* pin _0288_
* pin _0289_
* pin _0290_
* pin _0291_
* pin _0293_
* pin _0294_
* pin _0295_
* pin _0296_
* pin _0297_
* pin _0298_
* pin _0300_
* pin _0301_
* pin _0302_
* pin _0303_
* pin _0304_
* pin _0305_
* pin _0306_
* pin _0307_
* pin _0308_
* pin _0309_
* pin _0310_
* pin _0311_
* pin _0312_
* pin _0313_
* pin _0314_
* pin _0315_
* pin _0317_
* pin _0318_
* pin _0320_
* pin _0321_
* pin _0322_
* pin _0323_
* pin _0324_
* pin _0325_
* pin _0326_
* pin _0327_
* pin _0328_
* pin _0330_
* pin _0331_
* pin _0332_
* pin _0333_
* pin _0334_
* pin _0335_
* pin _0336_
* pin _0337_
* pin _0338_
* pin _0339_
* pin _0342_
* pin _0343_
* pin _0344_
* pin _0347_
* pin _0348_
* pin _0350_
* pin _0351_
* pin _0352_
* pin _0353_
* pin _0356_
* pin _0359_
* pin _0362_
* pin _0365_
* pin _0368_
* pin _0369_
* pin _0370_
* pin _0371_
* pin _0372_
* pin _0373_
* pin _0374_
* pin _0375_
* pin _0376_
* pin _0377_
* pin _0378_
* pin _0379_
* pin _0380_
* pin _0381_
* pin _0383_
* pin _0384_
* pin _0385_
* pin _0386_
* pin _0387_
* pin _0388_
* pin _0389_
* pin _0390_
* pin _0391_
* pin _0392_
* pin _0393_
* pin _0394_
* pin _0396_
* pin _0397_
* pin _0399_
* pin _0401_
* pin _0402_
* pin _0403_
* pin _0404_
* pin _0405_
* pin _0406_
* pin _0407_
* pin _0408_
* pin _0409_
* pin _0410_
* pin _0411_
* pin _0412_
* pin _0413_
* pin _0414_
* pin _0415_
* pin _0416_
* pin _0417_
* pin _0418_
* pin _0419_
* pin _0420_
* pin _0421_
* pin _0422_
* pin _0423_
* pin _0424_
* pin _0425_
* pin _0426_
* pin _0427_
* pin _0428_
* pin _0429_
* pin _0430_
* pin _0431_
* pin _0432_
* pin _0433_
* pin _0434_
* pin _0435_
* pin _0436_
* pin _0437_
* pin _0438_
* pin _0439_
* pin _0440_
* pin _0443_
* pin _0444_
* pin _0445_
* pin _0446_
* pin _0447_
* pin _0449_
* pin _0450_
* pin _0452_
* pin _0453_
* pin _0454_
* pin _0455_
* pin _0458_
* pin _0459_
* pin _0460_
* pin _0461_
* pin _0462_
* pin _0463_
* pin _0464_
* pin _0465_
* pin _0466_
* pin _0467_
* pin _0468_
* pin _0469_
* pin _0470_
* pin _0472_
* pin _0475_
* pin _0476_
* pin _0478_
* pin _0479_
* pin _0482_
* pin _0483_
* pin _0485_
* pin _0487_
* pin _0488_
* pin _0489_
* pin _0490_
* pin _0491_
* pin _0493_
* pin _0495_
* pin _0496_
* pin _0498_
* pin _0500_
* pin _0504_
* pin _0505_
* pin _0506_
* pin _0508_
* pin _0511_
* pin _0512_
* pin _0513_
* pin _0514_
* pin _0516_
* pin _0517_
* pin _0518_
* pin _0519_
* pin _0521_
* pin _0522_
* pin _0523_
* pin _0524_
* pin _0525_
* pin _0526_
* pin _0527_
* pin _0529_
* pin _0530_
* pin _0531_
* pin _0532_
* pin _0534_
* pin _0537_
* pin _0538_
* pin _0539_
* pin _0540_
* pin _0541_
* pin _0542_
* pin _0543_
* pin _0544_
* pin _0545_
* pin _0546_
* pin _0547_
* pin _0549_
* pin _0550_
* pin _0551_
* pin _0552_
* pin _0553_
* pin _0554_
* pin _0555_
* pin _0556_
* pin _0557_
* pin _0558_
* pin _0559_
* pin _0560_
* pin _0561_
* pin _0562_
* pin _0563_
* pin _0564_
* pin _0566_
* pin _0567_
* pin _0568_
* pin _0569_
* pin _0570_
* pin _0571_
* pin _0572_
* pin _0573_
* pin _0574_
* pin _0575_
* pin _0576_
* pin _0577_
* pin _0578_
* pin _0579_
* pin _0580_
* pin _0581_
* pin _0582_
* pin _0583_
* pin _0584_
* pin _0585_
* pin _0586_
* pin _0587_
* pin _0588_
* pin _0589_
* pin _0590_
* pin _0591_
* pin _0592_
* pin _0593_
* pin _0594_
* pin _0595_
* pin _0596_
* pin _0597_
* pin _0598_
* pin _0599_
* pin _0600_
* pin _0601_
* pin _0602_
* pin _0603_
* pin _0604_
* pin _0605_
* pin _0606_
* pin _0607_
* pin _0608_
* pin _0609_
* pin _0610_
* pin _0611_
* pin _0612_
* pin _0613_
* pin _0614_
* pin _0615_
* pin _0616_
* pin _0617_
* pin _0618_
* pin _0619_
* pin _0620_
* pin _0621_
* pin _0622_
* pin _0623_
* pin _0624_
* pin _0625_
* pin _0626_
* pin _0627_
* pin _0628_
* pin _0629_
* pin _0630_
* pin _0631_
* pin _0632_
* pin _0633_
* pin _0634_
* pin _0635_
* pin _0636_
* pin _0637_
* pin _0638_
* pin _0639_
* pin _0640_
* pin _0641_
* pin _0642_
* pin _0643_
* pin _0644_
* pin _0645_
* pin _0646_
* pin _0647_
* pin _0648_
* pin _0650_
* pin _0651_
* pin _0652_
* pin _0653_
* pin _0654_
* pin _0655_
* pin _0656_
* pin _0657_
* pin _0658_
* pin _0659_
* pin _0660_
* pin _0661_
* pin _0662_
* pin _0663_
* pin _0664_
* pin _0665_
* pin _0666_
* pin _0667_
* pin _0668_
* pin _0669_
* pin _0670_
* pin _0671_
* pin _0672_
* pin _0673_
* pin _0674_
* pin _0675_
* pin _0676_
* pin _0677_
* pin _0678_
* pin _0679_
* pin _0680_
* pin _0681_
* pin _0682_
* pin _0683_
* pin _0684_
* pin _0685_
* pin _0686_
* pin _0687_
* pin _0688_
* pin _0689_
* pin _0690_
* pin _0691_
* pin _0695_
* pin _0696_
* pin _0698_
* pin _0699_
* pin _0700_
* pin _0701_
* pin _0705_
* pin _0706_
* pin _0707_
* pin _0708_
* pin _0709_
* pin _0710_
* pin _0711_
* pin _0712_
* pin _0713_
* pin _0715_
* pin _0716_
* pin _0717_
* pin _0718_
* pin _0719_
* pin _0720_
* pin _0721_
* pin _0722_
* pin _0723_
* pin _0724_
* pin _0725_
* pin _0726_
* pin _0727_
* pin _0728_
* pin _0729_
* pin _0730_
* pin _0731_
* pin _0732_
* pin _0733_
* pin _0734_
* pin _0735_
* pin _0736_
* pin _0737_
* pin _0738_
* pin _0739_
* pin _0740_
* pin _0741_
* pin _0742_
* pin _0743_
* pin _0744_
* pin _0745_
* pin _0746_
* pin _0747_
* pin _0748_
* pin _0749_
* pin _0750_
* pin _0751_
* pin _0752_
* pin _0753_
* pin _0754_
* pin _0755_
* pin _0756_
* pin _0757_
* pin _0758_
* pin _0759_
* pin _0760_
* pin _0761_
* pin _0762_
* pin _0763_
* pin _0764_
* pin _0765_
* pin _0766_
* pin _0767_
* pin _0768_
* pin _0769_
* pin _0770_
* pin _0771_
* pin _0772_
* pin addr[0]
* pin addr[1]
* pin addr[2]
* pin addr[3]
* pin busy_r
* pin cal_r[0][0]
* pin cal_r[0][10]
* pin cal_r[0][11]
* pin cal_r[0][12]
* pin cal_r[0][13]
* pin cal_r[0][14]
* pin cal_r[0][15]
* pin cal_r[0][16]
* pin cal_r[0][17]
* pin cal_r[0][18]
* pin cal_r[0][19]
* pin cal_r[0][1]
* pin cal_r[0][20]
* pin cal_r[0][21]
* pin cal_r[0][22]
* pin cal_r[0][23]
* pin cal_r[0][2]
* pin cal_r[0][3]
* pin cal_r[0][4]
* pin cal_r[0][5]
* pin cal_r[0][6]
* pin cal_r[0][7]
* pin cal_r[0][8]
* pin cal_r[0][9]
* pin cal_r[1][0]
* pin cal_r[1][10]
* pin cal_r[1][11]
* pin cal_r[1][12]
* pin cal_r[1][13]
* pin cal_r[1][14]
* pin cal_r[1][15]
* pin cal_r[1][16]
* pin cal_r[1][17]
* pin cal_r[1][18]
* pin cal_r[1][19]
* pin cal_r[1][1]
* pin cal_r[1][20]
* pin cal_r[1][21]
* pin cal_r[1][22]
* pin cal_r[1][23]
* pin cal_r[1][2]
* pin cal_r[1][3]
* pin cal_r[1][4]
* pin cal_r[1][5]
* pin cal_r[1][6]
* pin cal_r[1][7]
* pin cal_r[1][8]
* pin cal_r[1][9]
* pin cal_r[2][0]
* pin cal_r[2][10]
* pin cal_r[2][11]
* pin cal_r[2][12]
* pin cal_r[2][13]
* pin cal_r[2][14]
* pin cal_r[2][15]
* pin cal_r[2][16]
* pin cal_r[2][17]
* pin cal_r[2][18]
* pin cal_r[2][19]
* pin cal_r[2][1]
* pin cal_r[2][20]
* pin cal_r[2][21]
* pin cal_r[2][22]
* pin cal_r[2][23]
* pin cal_r[2][2]
* pin cal_r[2][3]
* pin cal_r[2][4]
* pin cal_r[2][5]
* pin cal_r[2][6]
* pin cal_r[2][7]
* pin cal_r[2][8]
* pin cal_r[2][9]
* pin cal_r[3][0]
* pin cal_r[3][10]
* pin cal_r[3][11]
* pin cal_r[3][12]
* pin cal_r[3][13]
* pin cal_r[3][14]
* pin cal_r[3][15]
* pin cal_r[3][16]
* pin cal_r[3][17]
* pin cal_r[3][18]
* pin cal_r[3][19]
* pin cal_r[3][1]
* pin cal_r[3][20]
* pin cal_r[3][21]
* pin cal_r[3][22]
* pin cal_r[3][23]
* pin cal_r[3][2]
* pin cal_r[3][3]
* pin cal_r[3][4]
* pin cal_r[3][5]
* pin cal_r[3][6]
* pin cal_r[3][7]
* pin cal_r[3][8]
* pin cal_r[3][9]
* pin cal_r[4][0]
* pin cal_r[4][10]
* pin cal_r[4][11]
* pin cal_r[4][12]
* pin cal_r[4][13]
* pin cal_r[4][14]
* pin cal_r[4][15]
* pin cal_r[4][16]
* pin cal_r[4][17]
* pin cal_r[4][18]
* pin cal_r[4][19]
* pin cal_r[4][1]
* pin cal_r[4][20]
* pin cal_r[4][21]
* pin cal_r[4][22]
* pin cal_r[4][23]
* pin cal_r[4][2]
* pin cal_r[4][3]
* pin cal_r[4][4]
* pin cal_r[4][5]
* pin cal_r[4][6]
* pin cal_r[4][7]
* pin cal_r[4][8]
* pin cal_r[4][9]
* pin clk_ref
* pin clknet_0_clk_ref
* pin clknet_2_0__leaf_clk_ref
* pin clknet_2_1__leaf_clk_ref
* pin clknet_2_2__leaf_clk_ref
* pin clknet_2_3__leaf_clk_ref
* pin clknet_leaf_0_clk_ref
* pin clknet_leaf_10_clk_ref
* pin clknet_leaf_11_clk_ref
* pin clknet_leaf_12_clk_ref
* pin clknet_leaf_13_clk_ref
* pin clknet_leaf_14_clk_ref
* pin clknet_leaf_15_clk_ref
* pin clknet_leaf_16_clk_ref
* pin clknet_leaf_17_clk_ref
* pin clknet_leaf_18_clk_ref
* pin clknet_leaf_19_clk_ref
* pin clknet_leaf_1_clk_ref
* pin clknet_leaf_20_clk_ref
* pin clknet_leaf_21_clk_ref
* pin clknet_leaf_22_clk_ref
* pin clknet_leaf_23_clk_ref
* pin clknet_leaf_24_clk_ref
* pin clknet_leaf_25_clk_ref
* pin clknet_leaf_26_clk_ref
* pin clknet_leaf_27_clk_ref
* pin clknet_leaf_28_clk_ref
* pin clknet_leaf_29_clk_ref
* pin clknet_leaf_2_clk_ref
* pin clknet_leaf_30_clk_ref
* pin clknet_leaf_31_clk_ref
* pin clknet_leaf_32_clk_ref
* pin clknet_leaf_33_clk_ref
* pin clknet_leaf_34_clk_ref
* pin clknet_leaf_35_clk_ref
* pin clknet_leaf_36_clk_ref
* pin clknet_leaf_37_clk_ref
* pin clknet_leaf_38_clk_ref
* pin clknet_leaf_39_clk_ref
* pin clknet_leaf_3_clk_ref
* pin clknet_leaf_40_clk_ref
* pin clknet_leaf_4_clk_ref
* pin clknet_leaf_5_clk_ref
* pin clknet_leaf_6_clk_ref
* pin clknet_leaf_7_clk_ref
* pin clknet_leaf_8_clk_ref
* pin clknet_leaf_9_clk_ref
* pin cnt_o[0]
* pin cnt_o[10]
* pin cnt_o[11]
* pin cnt_o[12]
* pin cnt_o[13]
* pin cnt_o[14]
* pin cnt_o[15]
* pin cnt_o[16]
* pin cnt_o[17]
* pin cnt_o[18]
* pin cnt_o[19]
* pin cnt_o[1]
* pin cnt_o[20]
* pin cnt_o[21]
* pin cnt_o[22]
* pin cnt_o[23]
* pin cnt_o[2]
* pin cnt_o[3]
* pin cnt_o[4]
* pin cnt_o[5]
* pin cnt_o[6]
* pin cnt_o[7]
* pin cnt_o[8]
* pin cnt_o[9]
* pin count_r[0][0]
* pin count_r[0][10]
* pin count_r[0][11]
* pin count_r[0][12]
* pin count_r[0][13]
* pin count_r[0][14]
* pin count_r[0][15]
* pin count_r[0][16]
* pin count_r[0][17]
* pin count_r[0][18]
* pin count_r[0][19]
* pin count_r[0][1]
* pin count_r[0][20]
* pin count_r[0][21]
* pin count_r[0][22]
* pin count_r[0][23]
* pin count_r[0][2]
* pin count_r[0][3]
* pin count_r[0][4]
* pin count_r[0][5]
* pin count_r[0][6]
* pin count_r[0][7]
* pin count_r[0][8]
* pin count_r[0][9]
* pin count_r[1][0]
* pin count_r[1][10]
* pin count_r[1][11]
* pin count_r[1][12]
* pin count_r[1][13]
* pin count_r[1][14]
* pin count_r[1][15]
* pin count_r[1][16]
* pin count_r[1][17]
* pin count_r[1][18]
* pin count_r[1][19]
* pin count_r[1][1]
* pin count_r[1][20]
* pin count_r[1][21]
* pin count_r[1][22]
* pin count_r[1][23]
* pin count_r[1][2]
* pin count_r[1][3]
* pin count_r[1][4]
* pin count_r[1][5]
* pin count_r[1][6]
* pin count_r[1][7]
* pin count_r[1][8]
* pin count_r[1][9]
* pin count_r[2][0]
* pin count_r[2][10]
* pin count_r[2][11]
* pin count_r[2][12]
* pin count_r[2][13]
* pin count_r[2][14]
* pin count_r[2][15]
* pin count_r[2][16]
* pin count_r[2][17]
* pin count_r[2][18]
* pin count_r[2][19]
* pin count_r[2][1]
* pin count_r[2][20]
* pin count_r[2][21]
* pin count_r[2][22]
* pin count_r[2][23]
* pin count_r[2][2]
* pin count_r[2][3]
* pin count_r[2][4]
* pin count_r[2][5]
* pin count_r[2][6]
* pin count_r[2][7]
* pin count_r[2][8]
* pin count_r[2][9]
* pin count_r[3][0]
* pin count_r[3][10]
* pin count_r[3][11]
* pin count_r[3][12]
* pin count_r[3][13]
* pin count_r[3][14]
* pin count_r[3][15]
* pin count_r[3][16]
* pin count_r[3][17]
* pin count_r[3][18]
* pin count_r[3][19]
* pin count_r[3][1]
* pin count_r[3][20]
* pin count_r[3][21]
* pin count_r[3][22]
* pin count_r[3][23]
* pin count_r[3][2]
* pin count_r[3][3]
* pin count_r[3][4]
* pin count_r[3][5]
* pin count_r[3][6]
* pin count_r[3][7]
* pin count_r[3][8]
* pin count_r[3][9]
* pin count_r[4][0]
* pin count_r[4][10]
* pin count_r[4][11]
* pin count_r[4][12]
* pin count_r[4][13]
* pin count_r[4][14]
* pin count_r[4][15]
* pin count_r[4][16]
* pin count_r[4][17]
* pin count_r[4][18]
* pin count_r[4][19]
* pin count_r[4][1]
* pin count_r[4][20]
* pin count_r[4][21]
* pin count_r[4][22]
* pin count_r[4][23]
* pin count_r[4][2]
* pin count_r[4][3]
* pin count_r[4][4]
* pin count_r[4][5]
* pin count_r[4][6]
* pin count_r[4][7]
* pin count_r[4][8]
* pin count_r[4][9]
* pin ctrl_k[0]
* pin ctrl_k[1]
* pin ctrl_k[2]
* pin ctrl_k[3]
* pin ctrl_k[4]
* pin ctrl_sel[0]
* pin ctrl_sel[1]
* pin ctrl_sel[2]
* pin done_r
* pin gate_cnt[0]
* pin gate_cnt[10]
* pin gate_cnt[11]
* pin gate_cnt[12]
* pin gate_cnt[13]
* pin gate_cnt[14]
* pin gate_cnt[15]
* pin gate_cnt[16]
* pin gate_cnt[17]
* pin gate_cnt[18]
* pin gate_cnt[19]
* pin gate_cnt[1]
* pin gate_cnt[20]
* pin gate_cnt[21]
* pin gate_cnt[22]
* pin gate_cnt[23]
* pin gate_cnt[24]
* pin gate_cnt[25]
* pin gate_cnt[26]
* pin gate_cnt[27]
* pin gate_cnt[28]
* pin gate_cnt[29]
* pin gate_cnt[2]
* pin gate_cnt[30]
* pin gate_cnt[31]
* pin gate_cnt[3]
* pin gate_cnt[4]
* pin gate_cnt[5]
* pin gate_cnt[6]
* pin gate_cnt[7]
* pin gate_cnt[8]
* pin gate_cnt[9]
* pin gate_en
* pin k_q[0]
* pin k_q[1]
* pin k_q[2]
* pin k_q[3]
* pin k_q[4]
* pin net10
* pin net11
* pin net12
* pin net13
* pin net14
* pin net15
* pin net16
* pin net17
* pin net18
* pin net19
* pin net20
* pin net21
* pin net22
* pin osc[0]
* pin osc[1]
* pin osc[2]
* pin osc[3]
* pin osc[4]
* pin osc_sel_clk
* pin ovf_o
* pin ovf_r
* pin rdata[0]
* pin rdata[10]
* pin rdata[11]
* pin rdata[12]
* pin rdata[13]
* pin rdata[14]
* pin rdata[15]
* pin rdata[16]
* pin rdata[17]
* pin rdata[18]
* pin rdata[19]
* pin rdata[1]
* pin rdata[20]
* pin rdata[21]
* pin rdata[22]
* pin rdata[23]
* pin rdata[2]
* pin rdata[3]
* pin rdata[4]
* pin rdata[5]
* pin rdata[6]
* pin rdata[7]
* pin rdata[8]
* pin rdata[9]
* pin rst_n
* pin sel_q[0]
* pin sel_q[1]
* pin sel_q[2]
* pin tog_o
* pin tog_s1
* pin tog_s2
* pin tog_s3
* pin u_cnt/_000_
* pin u_cnt/_001_
* pin u_cnt/_002_
* pin u_cnt/_003_
* pin u_cnt/_004_
* pin u_cnt/_005_
* pin u_cnt/_006_
* pin u_cnt/_007_
* pin u_cnt/_008_
* pin u_cnt/_009_
* pin u_cnt/_010_
* pin u_cnt/_011_
* pin u_cnt/_012_
* pin u_cnt/_013_
* pin u_cnt/_014_
* pin u_cnt/_015_
* pin u_cnt/_016_
* pin u_cnt/_017_
* pin u_cnt/_018_
* pin u_cnt/_019_
* pin u_cnt/_020_
* pin u_cnt/_021_
* pin u_cnt/_022_
* pin u_cnt/_023_
* pin u_cnt/_024_
* pin u_cnt/_025_
* pin u_cnt/_026_
* pin u_cnt/_027_
* pin u_cnt/_028_
* pin u_cnt/_029_
* pin u_cnt/_030_
* pin u_cnt/_031_
* pin u_cnt/_032_
* pin u_cnt/_033_
* pin u_cnt/_034_
* pin u_cnt/_035_
* pin u_cnt/_036_
* pin u_cnt/_037_
* pin u_cnt/_038_
* pin u_cnt/_039_
* pin u_cnt/_040_
* pin u_cnt/_041_
* pin u_cnt/_042_
* pin u_cnt/_043_
* pin u_cnt/_044_
* pin u_cnt/_045_
* pin u_cnt/_046_
* pin u_cnt/_047_
* pin u_cnt/_048_
* pin u_cnt/_049_
* pin u_cnt/_050_
* pin u_cnt/_051_
* pin u_cnt/_052_
* pin u_cnt/_053_
* pin u_cnt/_054_
* pin u_cnt/_055_
* pin u_cnt/_056_
* pin u_cnt/_057_
* pin u_cnt/_058_
* pin u_cnt/_059_
* pin u_cnt/_060_
* pin u_cnt/_061_
* pin u_cnt/_062_
* pin u_cnt/_063_
* pin u_cnt/_064_
* pin u_cnt/_065_
* pin u_cnt/_066_
* pin u_cnt/_067_
* pin u_cnt/_068_
* pin u_cnt/_069_
* pin u_cnt/_070_
* pin u_cnt/_071_
* pin u_cnt/_072_
* pin u_cnt/_073_
* pin u_cnt/_074_
* pin u_cnt/_075_
* pin u_cnt/_076_
* pin u_cnt/_077_
* pin u_cnt/_078_
* pin u_cnt/_079_
* pin u_cnt/_080_
* pin u_cnt/_081_
* pin u_cnt/_082_
* pin u_cnt/_083_
* pin u_cnt/_084_
* pin u_cnt/_086_
* pin u_cnt/_088_
* pin u_cnt/_090_
* pin u_cnt/_093_
* pin u_cnt/_094_
* pin u_cnt/_095_
* pin u_cnt/_096_
* pin u_cnt/_097_
* pin u_cnt/_099_
* pin u_cnt/_100_
* pin u_cnt/_101_
* pin u_cnt/_102_
* pin u_cnt/_103_
* pin u_cnt/_104_
* pin u_cnt/_105_
* pin u_cnt/_106_
* pin u_cnt/gate_s1
* pin u_cnt/gate_s2
* pin u_cnt/running
* pin wdata[0]
* pin wdata[10]
* pin wdata[11]
* pin wdata[12]
* pin wdata[13]
* pin wdata[14]
* pin wdata[15]
* pin wdata[16]
* pin wdata[17]
* pin wdata[18]
* pin wdata[19]
* pin wdata[1]
* pin wdata[20]
* pin wdata[21]
* pin wdata[22]
* pin wdata[23]
* pin wdata[2]
* pin wdata[3]
* pin wdata[4]
* pin wdata[5]
* pin wdata[6]
* pin wdata[7]
* pin wdata[8]
* pin wdata[9]
* pin we
.SUBCKT readout VDD VSS \_0000_ \_0001_ \_0002_ \_0003_ \_0004_ \_0005_ \_0006_
+ \_0007_ \_0008_ \_0009_ \_0010_ \_0011_ \_0012_ \_0013_ \_0014_ \_0015_
+ \_0016_ \_0017_ \_0018_ \_0019_ \_0020_ \_0021_ \_0022_ \_0023_ \_0024_
+ \_0025_ \_0026_ \_0027_ \_0028_ \_0029_ \_0030_ \_0031_ \_0032_ \_0033_
+ \_0034_ \_0035_ \_0036_ \_0037_ \_0038_ \_0039_ \_0040_ \_0041_ \_0042_
+ \_0043_ \_0044_ \_0045_ \_0046_ \_0047_ \_0048_ \_0049_ \_0050_ \_0051_
+ \_0052_ \_0053_ \_0054_ \_0055_ \_0056_ \_0057_ \_0058_ \_0059_ \_0060_
+ \_0061_ \_0062_ \_0063_ \_0064_ \_0065_ \_0066_ \_0067_ \_0068_ \_0069_
+ \_0070_ \_0071_ \_0072_ \_0073_ \_0074_ \_0075_ \_0076_ \_0077_ \_0078_
+ \_0079_ \_0080_ \_0081_ \_0082_ \_0083_ \_0084_ \_0085_ \_0086_ \_0087_
+ \_0088_ \_0089_ \_0090_ \_0091_ \_0092_ \_0093_ \_0094_ \_0095_ \_0096_
+ \_0097_ \_0098_ \_0099_ \_0100_ \_0101_ \_0102_ \_0103_ \_0104_ \_0105_
+ \_0106_ \_0107_ \_0108_ \_0109_ \_0110_ \_0111_ \_0112_ \_0113_ \_0114_
+ \_0115_ \_0116_ \_0117_ \_0118_ \_0119_ \_0120_ \_0121_ \_0122_ \_0123_
+ \_0124_ \_0125_ \_0126_ \_0127_ \_0128_ \_0129_ \_0130_ \_0131_ \_0132_
+ \_0133_ \_0134_ \_0135_ \_0136_ \_0137_ \_0138_ \_0139_ \_0140_ \_0141_
+ \_0142_ \_0143_ \_0144_ \_0145_ \_0146_ \_0147_ \_0148_ \_0149_ \_0150_
+ \_0151_ \_0152_ \_0153_ \_0154_ \_0155_ \_0156_ \_0157_ \_0158_ \_0159_
+ \_0160_ \_0161_ \_0162_ \_0163_ \_0164_ \_0165_ \_0166_ \_0167_ \_0168_
+ \_0169_ \_0170_ \_0171_ \_0172_ \_0173_ \_0174_ \_0175_ \_0176_ \_0177_
+ \_0178_ \_0179_ \_0180_ \_0181_ \_0182_ \_0183_ \_0184_ \_0185_ \_0186_
+ \_0187_ \_0188_ \_0189_ \_0190_ \_0191_ \_0192_ \_0193_ \_0194_ \_0195_
+ \_0196_ \_0197_ \_0198_ \_0199_ \_0200_ \_0201_ \_0202_ \_0203_ \_0204_
+ \_0205_ \_0206_ \_0207_ \_0208_ \_0209_ \_0210_ \_0211_ \_0212_ \_0213_
+ \_0214_ \_0215_ \_0216_ \_0217_ \_0218_ \_0219_ \_0220_ \_0221_ \_0222_
+ \_0223_ \_0224_ \_0225_ \_0226_ \_0227_ \_0228_ \_0229_ \_0230_ \_0231_
+ \_0232_ \_0233_ \_0234_ \_0235_ \_0236_ \_0237_ \_0238_ \_0239_ \_0240_
+ \_0241_ \_0242_ \_0243_ \_0244_ \_0245_ \_0246_ \_0247_ \_0248_ \_0249_
+ \_0250_ \_0251_ \_0252_ \_0253_ \_0254_ \_0255_ \_0256_ \_0257_ \_0258_
+ \_0259_ \_0260_ \_0261_ \_0262_ \_0263_ \_0264_ \_0265_ \_0266_ \_0267_
+ \_0268_ \_0269_ \_0270_ \_0271_ \_0272_ \_0273_ \_0274_ \_0275_ \_0276_
+ \_0277_ \_0278_ \_0279_ \_0280_ \_0281_ \_0282_ \_0283_ \_0284_ \_0285_
+ \_0286_ \_0287_ \_0288_ \_0289_ \_0290_ \_0291_ \_0293_ \_0294_ \_0295_
+ \_0296_ \_0297_ \_0298_ \_0300_ \_0301_ \_0302_ \_0303_ \_0304_ \_0305_
+ \_0306_ \_0307_ \_0308_ \_0309_ \_0310_ \_0311_ \_0312_ \_0313_ \_0314_
+ \_0315_ \_0317_ \_0318_ \_0320_ \_0321_ \_0322_ \_0323_ \_0324_ \_0325_
+ \_0326_ \_0327_ \_0328_ \_0330_ \_0331_ \_0332_ \_0333_ \_0334_ \_0335_
+ \_0336_ \_0337_ \_0338_ \_0339_ \_0342_ \_0343_ \_0344_ \_0347_ \_0348_
+ \_0350_ \_0351_ \_0352_ \_0353_ \_0356_ \_0359_ \_0362_ \_0365_ \_0368_
+ \_0369_ \_0370_ \_0371_ \_0372_ \_0373_ \_0374_ \_0375_ \_0376_ \_0377_
+ \_0378_ \_0379_ \_0380_ \_0381_ \_0383_ \_0384_ \_0385_ \_0386_ \_0387_
+ \_0388_ \_0389_ \_0390_ \_0391_ \_0392_ \_0393_ \_0394_ \_0396_ \_0397_
+ \_0399_ \_0401_ \_0402_ \_0403_ \_0404_ \_0405_ \_0406_ \_0407_ \_0408_
+ \_0409_ \_0410_ \_0411_ \_0412_ \_0413_ \_0414_ \_0415_ \_0416_ \_0417_
+ \_0418_ \_0419_ \_0420_ \_0421_ \_0422_ \_0423_ \_0424_ \_0425_ \_0426_
+ \_0427_ \_0428_ \_0429_ \_0430_ \_0431_ \_0432_ \_0433_ \_0434_ \_0435_
+ \_0436_ \_0437_ \_0438_ \_0439_ \_0440_ \_0443_ \_0444_ \_0445_ \_0446_
+ \_0447_ \_0449_ \_0450_ \_0452_ \_0453_ \_0454_ \_0455_ \_0458_ \_0459_
+ \_0460_ \_0461_ \_0462_ \_0463_ \_0464_ \_0465_ \_0466_ \_0467_ \_0468_
+ \_0469_ \_0470_ \_0472_ \_0475_ \_0476_ \_0478_ \_0479_ \_0482_ \_0483_
+ \_0485_ \_0487_ \_0488_ \_0489_ \_0490_ \_0491_ \_0493_ \_0495_ \_0496_
+ \_0498_ \_0500_ \_0504_ \_0505_ \_0506_ \_0508_ \_0511_ \_0512_ \_0513_
+ \_0514_ \_0516_ \_0517_ \_0518_ \_0519_ \_0521_ \_0522_ \_0523_ \_0524_
+ \_0525_ \_0526_ \_0527_ \_0529_ \_0530_ \_0531_ \_0532_ \_0534_ \_0537_
+ \_0538_ \_0539_ \_0540_ \_0541_ \_0542_ \_0543_ \_0544_ \_0545_ \_0546_
+ \_0547_ \_0549_ \_0550_ \_0551_ \_0552_ \_0553_ \_0554_ \_0555_ \_0556_
+ \_0557_ \_0558_ \_0559_ \_0560_ \_0561_ \_0562_ \_0563_ \_0564_ \_0566_
+ \_0567_ \_0568_ \_0569_ \_0570_ \_0571_ \_0572_ \_0573_ \_0574_ \_0575_
+ \_0576_ \_0577_ \_0578_ \_0579_ \_0580_ \_0581_ \_0582_ \_0583_ \_0584_
+ \_0585_ \_0586_ \_0587_ \_0588_ \_0589_ \_0590_ \_0591_ \_0592_ \_0593_
+ \_0594_ \_0595_ \_0596_ \_0597_ \_0598_ \_0599_ \_0600_ \_0601_ \_0602_
+ \_0603_ \_0604_ \_0605_ \_0606_ \_0607_ \_0608_ \_0609_ \_0610_ \_0611_
+ \_0612_ \_0613_ \_0614_ \_0615_ \_0616_ \_0617_ \_0618_ \_0619_ \_0620_
+ \_0621_ \_0622_ \_0623_ \_0624_ \_0625_ \_0626_ \_0627_ \_0628_ \_0629_
+ \_0630_ \_0631_ \_0632_ \_0633_ \_0634_ \_0635_ \_0636_ \_0637_ \_0638_
+ \_0639_ \_0640_ \_0641_ \_0642_ \_0643_ \_0644_ \_0645_ \_0646_ \_0647_
+ \_0648_ \_0650_ \_0651_ \_0652_ \_0653_ \_0654_ \_0655_ \_0656_ \_0657_
+ \_0658_ \_0659_ \_0660_ \_0661_ \_0662_ \_0663_ \_0664_ \_0665_ \_0666_
+ \_0667_ \_0668_ \_0669_ \_0670_ \_0671_ \_0672_ \_0673_ \_0674_ \_0675_
+ \_0676_ \_0677_ \_0678_ \_0679_ \_0680_ \_0681_ \_0682_ \_0683_ \_0684_
+ \_0685_ \_0686_ \_0687_ \_0688_ \_0689_ \_0690_ \_0691_ \_0695_ \_0696_
+ \_0698_ \_0699_ \_0700_ \_0701_ \_0705_ \_0706_ \_0707_ \_0708_ \_0709_
+ \_0710_ \_0711_ \_0712_ \_0713_ \_0715_ \_0716_ \_0717_ \_0718_ \_0719_
+ \_0720_ \_0721_ \_0722_ \_0723_ \_0724_ \_0725_ \_0726_ \_0727_ \_0728_
+ \_0729_ \_0730_ \_0731_ \_0732_ \_0733_ \_0734_ \_0735_ \_0736_ \_0737_
+ \_0738_ \_0739_ \_0740_ \_0741_ \_0742_ \_0743_ \_0744_ \_0745_ \_0746_
+ \_0747_ \_0748_ \_0749_ \_0750_ \_0751_ \_0752_ \_0753_ \_0754_ \_0755_
+ \_0756_ \_0757_ \_0758_ \_0759_ \_0760_ \_0761_ \_0762_ \_0763_ \_0764_
+ \_0765_ \_0766_ \_0767_ \_0768_ \_0769_ \_0770_ \_0771_ \_0772_ addr[0]
+ addr[1] addr[2] addr[3] busy_r cal_r[0][0] cal_r[0][10] cal_r[0][11]
+ cal_r[0][12] cal_r[0][13] cal_r[0][14] cal_r[0][15] cal_r[0][16] cal_r[0][17]
+ cal_r[0][18] cal_r[0][19] cal_r[0][1] cal_r[0][20] cal_r[0][21] cal_r[0][22]
+ cal_r[0][23] cal_r[0][2] cal_r[0][3] cal_r[0][4] cal_r[0][5] cal_r[0][6]
+ cal_r[0][7] cal_r[0][8] cal_r[0][9] cal_r[1][0] cal_r[1][10] cal_r[1][11]
+ cal_r[1][12] cal_r[1][13] cal_r[1][14] cal_r[1][15] cal_r[1][16] cal_r[1][17]
+ cal_r[1][18] cal_r[1][19] cal_r[1][1] cal_r[1][20] cal_r[1][21] cal_r[1][22]
+ cal_r[1][23] cal_r[1][2] cal_r[1][3] cal_r[1][4] cal_r[1][5] cal_r[1][6]
+ cal_r[1][7] cal_r[1][8] cal_r[1][9] cal_r[2][0] cal_r[2][10] cal_r[2][11]
+ cal_r[2][12] cal_r[2][13] cal_r[2][14] cal_r[2][15] cal_r[2][16] cal_r[2][17]
+ cal_r[2][18] cal_r[2][19] cal_r[2][1] cal_r[2][20] cal_r[2][21] cal_r[2][22]
+ cal_r[2][23] cal_r[2][2] cal_r[2][3] cal_r[2][4] cal_r[2][5] cal_r[2][6]
+ cal_r[2][7] cal_r[2][8] cal_r[2][9] cal_r[3][0] cal_r[3][10] cal_r[3][11]
+ cal_r[3][12] cal_r[3][13] cal_r[3][14] cal_r[3][15] cal_r[3][16] cal_r[3][17]
+ cal_r[3][18] cal_r[3][19] cal_r[3][1] cal_r[3][20] cal_r[3][21] cal_r[3][22]
+ cal_r[3][23] cal_r[3][2] cal_r[3][3] cal_r[3][4] cal_r[3][5] cal_r[3][6]
+ cal_r[3][7] cal_r[3][8] cal_r[3][9] cal_r[4][0] cal_r[4][10] cal_r[4][11]
+ cal_r[4][12] cal_r[4][13] cal_r[4][14] cal_r[4][15] cal_r[4][16] cal_r[4][17]
+ cal_r[4][18] cal_r[4][19] cal_r[4][1] cal_r[4][20] cal_r[4][21] cal_r[4][22]
+ cal_r[4][23] cal_r[4][2] cal_r[4][3] cal_r[4][4] cal_r[4][5] cal_r[4][6]
+ cal_r[4][7] cal_r[4][8] cal_r[4][9] clk_ref clknet_0_clk_ref
+ clknet_2_0__leaf_clk_ref clknet_2_1__leaf_clk_ref clknet_2_2__leaf_clk_ref
+ clknet_2_3__leaf_clk_ref clknet_leaf_0_clk_ref clknet_leaf_10_clk_ref
+ clknet_leaf_11_clk_ref clknet_leaf_12_clk_ref clknet_leaf_13_clk_ref
+ clknet_leaf_14_clk_ref clknet_leaf_15_clk_ref clknet_leaf_16_clk_ref
+ clknet_leaf_17_clk_ref clknet_leaf_18_clk_ref clknet_leaf_19_clk_ref
+ clknet_leaf_1_clk_ref clknet_leaf_20_clk_ref clknet_leaf_21_clk_ref
+ clknet_leaf_22_clk_ref clknet_leaf_23_clk_ref clknet_leaf_24_clk_ref
+ clknet_leaf_25_clk_ref clknet_leaf_26_clk_ref clknet_leaf_27_clk_ref
+ clknet_leaf_28_clk_ref clknet_leaf_29_clk_ref clknet_leaf_2_clk_ref
+ clknet_leaf_30_clk_ref clknet_leaf_31_clk_ref clknet_leaf_32_clk_ref
+ clknet_leaf_33_clk_ref clknet_leaf_34_clk_ref clknet_leaf_35_clk_ref
+ clknet_leaf_36_clk_ref clknet_leaf_37_clk_ref clknet_leaf_38_clk_ref
+ clknet_leaf_39_clk_ref clknet_leaf_3_clk_ref clknet_leaf_40_clk_ref
+ clknet_leaf_4_clk_ref clknet_leaf_5_clk_ref clknet_leaf_6_clk_ref
+ clknet_leaf_7_clk_ref clknet_leaf_8_clk_ref clknet_leaf_9_clk_ref cnt_o[0]
+ cnt_o[10] cnt_o[11] cnt_o[12] cnt_o[13] cnt_o[14] cnt_o[15] cnt_o[16]
+ cnt_o[17] cnt_o[18] cnt_o[19] cnt_o[1] cnt_o[20] cnt_o[21] cnt_o[22]
+ cnt_o[23] cnt_o[2] cnt_o[3] cnt_o[4] cnt_o[5] cnt_o[6] cnt_o[7] cnt_o[8]
+ cnt_o[9] count_r[0][0] count_r[0][10] count_r[0][11] count_r[0][12]
+ count_r[0][13] count_r[0][14] count_r[0][15] count_r[0][16] count_r[0][17]
+ count_r[0][18] count_r[0][19] count_r[0][1] count_r[0][20] count_r[0][21]
+ count_r[0][22] count_r[0][23] count_r[0][2] count_r[0][3] count_r[0][4]
+ count_r[0][5] count_r[0][6] count_r[0][7] count_r[0][8] count_r[0][9]
+ count_r[1][0] count_r[1][10] count_r[1][11] count_r[1][12] count_r[1][13]
+ count_r[1][14] count_r[1][15] count_r[1][16] count_r[1][17] count_r[1][18]
+ count_r[1][19] count_r[1][1] count_r[1][20] count_r[1][21] count_r[1][22]
+ count_r[1][23] count_r[1][2] count_r[1][3] count_r[1][4] count_r[1][5]
+ count_r[1][6] count_r[1][7] count_r[1][8] count_r[1][9] count_r[2][0]
+ count_r[2][10] count_r[2][11] count_r[2][12] count_r[2][13] count_r[2][14]
+ count_r[2][15] count_r[2][16] count_r[2][17] count_r[2][18] count_r[2][19]
+ count_r[2][1] count_r[2][20] count_r[2][21] count_r[2][22] count_r[2][23]
+ count_r[2][2] count_r[2][3] count_r[2][4] count_r[2][5] count_r[2][6]
+ count_r[2][7] count_r[2][8] count_r[2][9] count_r[3][0] count_r[3][10]
+ count_r[3][11] count_r[3][12] count_r[3][13] count_r[3][14] count_r[3][15]
+ count_r[3][16] count_r[3][17] count_r[3][18] count_r[3][19] count_r[3][1]
+ count_r[3][20] count_r[3][21] count_r[3][22] count_r[3][23] count_r[3][2]
+ count_r[3][3] count_r[3][4] count_r[3][5] count_r[3][6] count_r[3][7]
+ count_r[3][8] count_r[3][9] count_r[4][0] count_r[4][10] count_r[4][11]
+ count_r[4][12] count_r[4][13] count_r[4][14] count_r[4][15] count_r[4][16]
+ count_r[4][17] count_r[4][18] count_r[4][19] count_r[4][1] count_r[4][20]
+ count_r[4][21] count_r[4][22] count_r[4][23] count_r[4][2] count_r[4][3]
+ count_r[4][4] count_r[4][5] count_r[4][6] count_r[4][7] count_r[4][8]
+ count_r[4][9] ctrl_k[0] ctrl_k[1] ctrl_k[2] ctrl_k[3] ctrl_k[4] ctrl_sel[0]
+ ctrl_sel[1] ctrl_sel[2] done_r gate_cnt[0] gate_cnt[10] gate_cnt[11]
+ gate_cnt[12] gate_cnt[13] gate_cnt[14] gate_cnt[15] gate_cnt[16] gate_cnt[17]
+ gate_cnt[18] gate_cnt[19] gate_cnt[1] gate_cnt[20] gate_cnt[21] gate_cnt[22]
+ gate_cnt[23] gate_cnt[24] gate_cnt[25] gate_cnt[26] gate_cnt[27] gate_cnt[28]
+ gate_cnt[29] gate_cnt[2] gate_cnt[30] gate_cnt[31] gate_cnt[3] gate_cnt[4]
+ gate_cnt[5] gate_cnt[6] gate_cnt[7] gate_cnt[8] gate_cnt[9] gate_en k_q[0]
+ k_q[1] k_q[2] k_q[3] k_q[4] net10 net11 net12 net13 net14 net15 net16 net17
+ net18 net19 net20 net21 net22 osc[0] osc[1] osc[2] osc[3] osc[4] osc_sel_clk
+ ovf_o ovf_r rdata[0] rdata[10] rdata[11] rdata[12] rdata[13] rdata[14]
+ rdata[15] rdata[16] rdata[17] rdata[18] rdata[19] rdata[1] rdata[20]
+ rdata[21] rdata[22] rdata[23] rdata[2] rdata[3] rdata[4] rdata[5] rdata[6]
+ rdata[7] rdata[8] rdata[9] rst_n sel_q[0] sel_q[1] sel_q[2] tog_o tog_s1
+ tog_s2 tog_s3 u_cnt/_000_ u_cnt/_001_ u_cnt/_002_ u_cnt/_003_ u_cnt/_004_
+ u_cnt/_005_ u_cnt/_006_ u_cnt/_007_ u_cnt/_008_ u_cnt/_009_ u_cnt/_010_
+ u_cnt/_011_ u_cnt/_012_ u_cnt/_013_ u_cnt/_014_ u_cnt/_015_ u_cnt/_016_
+ u_cnt/_017_ u_cnt/_018_ u_cnt/_019_ u_cnt/_020_ u_cnt/_021_ u_cnt/_022_
+ u_cnt/_023_ u_cnt/_024_ u_cnt/_025_ u_cnt/_026_ u_cnt/_027_ u_cnt/_028_
+ u_cnt/_029_ u_cnt/_030_ u_cnt/_031_ u_cnt/_032_ u_cnt/_033_ u_cnt/_034_
+ u_cnt/_035_ u_cnt/_036_ u_cnt/_037_ u_cnt/_038_ u_cnt/_039_ u_cnt/_040_
+ u_cnt/_041_ u_cnt/_042_ u_cnt/_043_ u_cnt/_044_ u_cnt/_045_ u_cnt/_046_
+ u_cnt/_047_ u_cnt/_048_ u_cnt/_049_ u_cnt/_050_ u_cnt/_051_ u_cnt/_052_
+ u_cnt/_053_ u_cnt/_054_ u_cnt/_055_ u_cnt/_056_ u_cnt/_057_ u_cnt/_058_
+ u_cnt/_059_ u_cnt/_060_ u_cnt/_061_ u_cnt/_062_ u_cnt/_063_ u_cnt/_064_
+ u_cnt/_065_ u_cnt/_066_ u_cnt/_067_ u_cnt/_068_ u_cnt/_069_ u_cnt/_070_
+ u_cnt/_071_ u_cnt/_072_ u_cnt/_073_ u_cnt/_074_ u_cnt/_075_ u_cnt/_076_
+ u_cnt/_077_ u_cnt/_078_ u_cnt/_079_ u_cnt/_080_ u_cnt/_081_ u_cnt/_082_
+ u_cnt/_083_ u_cnt/_084_ u_cnt/_086_ u_cnt/_088_ u_cnt/_090_ u_cnt/_093_
+ u_cnt/_094_ u_cnt/_095_ u_cnt/_096_ u_cnt/_097_ u_cnt/_099_ u_cnt/_100_
+ u_cnt/_101_ u_cnt/_102_ u_cnt/_103_ u_cnt/_104_ u_cnt/_105_ u_cnt/_106_
+ u_cnt/gate_s1 u_cnt/gate_s2 u_cnt/running wdata[0] wdata[10] wdata[11]
+ wdata[12] wdata[13] wdata[14] wdata[15] wdata[16] wdata[17] wdata[18]
+ wdata[19] wdata[1] wdata[20] wdata[21] wdata[22] wdata[23] wdata[2] wdata[3]
+ wdata[4] wdata[5] wdata[6] wdata[7] wdata[8] wdata[9] we
* cell instance sky130_fd_sc_hd__a2111oi_0_0 r0 *1 0,0
Xsky130_fd_sc_hd__a2111oi_0_0 gate_cnt[30] \_0754_ \_0306_ \_0312_ net13 VSS
+ VDD VDD \_0317_ sky130_fd_sc_hd__a2111oi_0
* cell instance sky130_fd_sc_hd__a211o_1_0 r0 *1 0,0
Xsky130_fd_sc_hd__a211o_1_0 ctrl_sel[2] \_0626_ \_0663_ \_0666_ VSS VDD VDD
+ rdata[3] sky130_fd_sc_hd__a211o_1
* cell instance sky130_fd_sc_hd__a211o_1_1 r0 *1 0,0
Xsky130_fd_sc_hd__a211o_1_1 ctrl_k[2] \_0626_ \_0640_ \_0643_ VSS VDD VDD
+ rdata[6] sky130_fd_sc_hd__a211o_1
* cell instance sky130_fd_sc_hd__a211o_1_2 r0 *1 0,0
Xsky130_fd_sc_hd__a211o_1_2 ctrl_k[3] \_0626_ \_0634_ \_0637_ VSS VDD VDD
+ rdata[7] sky130_fd_sc_hd__a211o_1
* cell instance sky130_fd_sc_hd__a211oi_1_0 r0 *1 0,0
Xsky130_fd_sc_hd__a211oi_1_0 gate_cnt[26] \_0396_ \_0399_ net13 VSS VDD VDD
+ \_0160_ sky130_fd_sc_hd__a211oi_1
* cell instance sky130_fd_sc_hd__a211oi_1_1 r0 *1 0,0
Xsky130_fd_sc_hd__a211oi_1_1 k_q[1] k_q[0] k_q[3] k_q[2] VSS VDD VDD \_0715_
+ sky130_fd_sc_hd__a211oi_1
* cell instance sky130_fd_sc_hd__a211oi_1_2 r0 *1 0,0
Xsky130_fd_sc_hd__a211oi_1_2 gate_cnt[19] \_0406_ \_0410_ net13 VSS VDD VDD
+ \_0167_ sky130_fd_sc_hd__a211oi_1
* cell instance sky130_fd_sc_hd__a211oi_1_3 r0 *1 0,0
Xsky130_fd_sc_hd__a211oi_1_3 u_cnt/_068_ u_cnt/_084_ u_cnt/_094_ u_cnt/_088_
+ VSS VDD VDD u_cnt/_002_ sky130_fd_sc_hd__a211oi_1
* cell instance sky130_fd_sc_hd__a211oi_1_4 r0 *1 0,0
Xsky130_fd_sc_hd__a211oi_1_4 gate_cnt[1] \_0295_ k_q[4] gate_cnt[15] VSS VDD
+ VDD \_0296_ sky130_fd_sc_hd__a211oi_1
* cell instance sky130_fd_sc_hd__a211oi_2_0 r0 *1 0,0
Xsky130_fd_sc_hd__a211oi_2_0 \_0387_ \_0396_ \_0397_ net13 VSS VDD VDD \_0159_
+ sky130_fd_sc_hd__a211oi_2
* cell instance sky130_fd_sc_hd__a21boi_0_0 r0 *1 0,0
Xsky130_fd_sc_hd__a21boi_0_0 u_cnt/_095_ u_cnt/_096_ cnt_o[0] VSS VDD VDD
+ u_cnt/_097_ sky130_fd_sc_hd__a21boi_0
* cell instance sky130_fd_sc_hd__a21o_1_0 r0 *1 0,0
Xsky130_fd_sc_hd__a21o_1_0 done_r \_0348_ \_0343_ VSS VDD VDD \_0212_
+ sky130_fd_sc_hd__a21o_1
* cell instance sky130_fd_sc_hd__a21o_1_1 r0 *1 0,0
Xsky130_fd_sc_hd__a21o_1_1 u_cnt/_079_ u_cnt/_084_ u_cnt/_088_ VSS VDD VDD
+ u_cnt/_026_ sky130_fd_sc_hd__a21o_1
* cell instance sky130_fd_sc_hd__a21oi_1_0 r0 *1 0,0
Xsky130_fd_sc_hd__a21oi_1_0 cal_r[4][12] net22 \_0596_ VSS VDD VDD \_0597_
+ sky130_fd_sc_hd__a21oi_1
* cell instance sky130_fd_sc_hd__a21oi_1_1 r0 *1 0,0
Xsky130_fd_sc_hd__a21oi_1_1 cal_r[1][22] net20 \_0505_ VSS VDD VDD \_0506_
+ sky130_fd_sc_hd__a21oi_1
* cell instance sky130_fd_sc_hd__a21oi_1_2 r0 *1 0,0
Xsky130_fd_sc_hd__a21oi_1_2 cal_r[1][15] net20 \_0568_ VSS VDD VDD \_0569_
+ sky130_fd_sc_hd__a21oi_1
* cell instance sky130_fd_sc_hd__a21oi_1_3 r0 *1 0,0
Xsky130_fd_sc_hd__a21oi_1_3 cal_r[2][19] net19 \_0538_ VSS VDD VDD \_0539_
+ sky130_fd_sc_hd__a21oi_1
* cell instance sky130_fd_sc_hd__a21oi_1_4 r0 *1 0,0
Xsky130_fd_sc_hd__a21oi_1_4 cal_r[2][13] \_0500_ \_0588_ VSS VDD VDD \_0589_
+ sky130_fd_sc_hd__a21oi_1
* cell instance sky130_fd_sc_hd__a21oi_1_5 r0 *1 0,0
Xsky130_fd_sc_hd__a21oi_1_5 cal_r[4][17] net22 \_0551_ VSS VDD VDD \_0552_
+ sky130_fd_sc_hd__a21oi_1
* cell instance sky130_fd_sc_hd__a21oi_1_6 r0 *1 0,0
Xsky130_fd_sc_hd__a21oi_1_6 cal_r[4][23] net21 \_0323_ VSS VDD VDD \_0324_
+ sky130_fd_sc_hd__a21oi_1
* cell instance sky130_fd_sc_hd__a21oi_1_7 r0 *1 0,0
Xsky130_fd_sc_hd__a21oi_1_7 \_0681_ \_0682_ \_0491_ VSS VDD VDD \_0683_
+ sky130_fd_sc_hd__a21oi_1
* cell instance sky130_fd_sc_hd__a21oi_1_8 r0 *1 0,0
Xsky130_fd_sc_hd__a21oi_1_8 ctrl_sel[0] \_0626_ \_0683_ VSS VDD VDD \_0684_
+ sky130_fd_sc_hd__a21oi_1
* cell instance sky130_fd_sc_hd__a21oi_1_9 r0 *1 0,0
Xsky130_fd_sc_hd__a21oi_1_9 cal_r[2][10] net19 \_0608_ VSS VDD VDD \_0609_
+ sky130_fd_sc_hd__a21oi_1
* cell instance sky130_fd_sc_hd__a21oi_1_10 r0 *1 0,0
Xsky130_fd_sc_hd__a21oi_1_10 cal_r[3][18] net15 \_0542_ VSS VDD VDD \_0543_
+ sky130_fd_sc_hd__a21oi_1
* cell instance sky130_fd_sc_hd__a21oi_1_11 r0 *1 0,0
Xsky130_fd_sc_hd__a21oi_1_11 cal_r[1][20] \_0493_ \_0526_ VSS VDD VDD \_0527_
+ sky130_fd_sc_hd__a21oi_1
* cell instance sky130_fd_sc_hd__a21oi_1_12 r0 *1 0,0
Xsky130_fd_sc_hd__a21oi_1_12 done_r \_0667_ \_0679_ VSS VDD VDD \_0680_
+ sky130_fd_sc_hd__a21oi_1
* cell instance sky130_fd_sc_hd__a21oi_1_13 r0 *1 0,0
Xsky130_fd_sc_hd__a21oi_1_13 cal_r[1][14] \_0493_ \_0576_ VSS VDD VDD \_0577_
+ sky130_fd_sc_hd__a21oi_1
* cell instance sky130_fd_sc_hd__a21oi_1_14 r0 *1 0,0
Xsky130_fd_sc_hd__a21oi_1_14 cal_r[1][21] \_0493_ \_0517_ VSS VDD VDD \_0518_
+ sky130_fd_sc_hd__a21oi_1
* cell instance sky130_fd_sc_hd__a21oi_1_15 r0 *1 0,0
Xsky130_fd_sc_hd__a21oi_1_15 ovf_r \_0667_ \_0670_ VSS VDD VDD \_0671_
+ sky130_fd_sc_hd__a21oi_1
* cell instance sky130_fd_sc_hd__a21oi_1_16 r0 *1 0,0
Xsky130_fd_sc_hd__a21oi_1_16 ctrl_sel[1] \_0626_ \_0675_ VSS VDD VDD \_0676_
+ sky130_fd_sc_hd__a21oi_1
* cell instance sky130_fd_sc_hd__a21oi_1_17 r0 *1 0,0
Xsky130_fd_sc_hd__a21oi_1_17 cal_r[1][16] \_0493_ \_0563_ VSS VDD VDD \_0564_
+ sky130_fd_sc_hd__a21oi_1
* cell instance sky130_fd_sc_hd__a21oi_1_18 r0 *1 0,0
Xsky130_fd_sc_hd__a21oi_1_18 cal_r[1][9] \_0493_ \_0616_ VSS VDD VDD \_0617_
+ sky130_fd_sc_hd__a21oi_1
* cell instance sky130_fd_sc_hd__a21oi_1_19 r0 *1 0,0
Xsky130_fd_sc_hd__a21oi_1_19 tog_s2 tog_s3 \_0342_ VSS VDD VDD \_0343_
+ sky130_fd_sc_hd__a21oi_1
* cell instance sky130_fd_sc_hd__a21oi_1_20 r0 *1 0,0
Xsky130_fd_sc_hd__a21oi_1_20 cal_r[1][11] net20 \_0604_ VSS VDD VDD \_0605_
+ sky130_fd_sc_hd__a21oi_1
* cell instance sky130_fd_sc_hd__a21oi_1_21 r0 *1 0,0
Xsky130_fd_sc_hd__a21oi_1_21 cal_r[1][4] net20 \_0655_ VSS VDD VDD \_0656_
+ sky130_fd_sc_hd__a21oi_1
* cell instance sky130_fd_sc_hd__a21oi_1_22 r0 *1 0,0
Xsky130_fd_sc_hd__a21oi_1_22 \_0452_ \_0343_ \_0453_ VSS VDD VDD \_0215_
+ sky130_fd_sc_hd__a21oi_1
* cell instance sky130_fd_sc_hd__a21oi_1_23 r0 *1 0,0
Xsky130_fd_sc_hd__a21oi_1_23 ovf_r \_0348_ \_0343_ VSS VDD VDD \_0453_
+ sky130_fd_sc_hd__a21oi_1
* cell instance sky130_fd_sc_hd__a21oi_1_24 r0 *1 0,0
Xsky130_fd_sc_hd__a21oi_1_24 \_0661_ \_0662_ \_0491_ VSS VDD VDD \_0663_
+ sky130_fd_sc_hd__a21oi_1
* cell instance sky130_fd_sc_hd__a21oi_1_25 r0 *1 0,0
Xsky130_fd_sc_hd__a21oi_1_25 osc[4] \_0335_ \_0336_ VSS VDD VDD \_0337_
+ sky130_fd_sc_hd__a21oi_1
* cell instance sky130_fd_sc_hd__a21oi_1_26 r0 *1 0,0
Xsky130_fd_sc_hd__a21oi_1_26 count_r[1][21] net15 \_0512_ VSS VDD VDD \_0513_
+ sky130_fd_sc_hd__a21oi_1
* cell instance sky130_fd_sc_hd__a21oi_1_27 r0 *1 0,0
Xsky130_fd_sc_hd__a21oi_1_27 \_0632_ \_0633_ \_0491_ VSS VDD VDD \_0634_
+ sky130_fd_sc_hd__a21oi_1
* cell instance sky130_fd_sc_hd__a21oi_1_28 r0 *1 0,0
Xsky130_fd_sc_hd__a21oi_1_28 count_r[1][20] net15 \_0522_ VSS VDD VDD \_0523_
+ sky130_fd_sc_hd__a21oi_1
* cell instance sky130_fd_sc_hd__a21oi_1_29 r0 *1 0,0
Xsky130_fd_sc_hd__a21oi_1_29 \_0641_ \_0642_ \_0491_ VSS VDD VDD \_0643_
+ sky130_fd_sc_hd__a21oi_1
* cell instance sky130_fd_sc_hd__a21oi_1_30 r0 *1 0,0
Xsky130_fd_sc_hd__a21oi_1_30 count_r[2][16] net21 \_0559_ VSS VDD VDD \_0560_
+ sky130_fd_sc_hd__a21oi_1
* cell instance sky130_fd_sc_hd__a21oi_1_31 r0 *1 0,0
Xsky130_fd_sc_hd__a21oi_1_31 cal_r[4][8] net22 \_0624_ VSS VDD VDD \_0625_
+ sky130_fd_sc_hd__a21oi_1
* cell instance sky130_fd_sc_hd__a21oi_1_32 r0 *1 0,0
Xsky130_fd_sc_hd__a21oi_1_32 count_r[1][17] net15 \_0555_ VSS VDD VDD \_0556_
+ sky130_fd_sc_hd__a21oi_1
* cell instance sky130_fd_sc_hd__a21oi_1_33 r0 *1 0,0
Xsky130_fd_sc_hd__a21oi_1_33 \_0468_ \_0466_ \_0467_ VSS VDD VDD \_0628_
+ sky130_fd_sc_hd__a21oi_1
* cell instance sky130_fd_sc_hd__a21oi_1_34 r0 *1 0,0
Xsky130_fd_sc_hd__a21oi_1_34 count_r[3][18] net16 \_0546_ VSS VDD VDD \_0547_
+ sky130_fd_sc_hd__a21oi_1
* cell instance sky130_fd_sc_hd__a21oi_1_35 r0 *1 0,0
Xsky130_fd_sc_hd__a21oi_1_35 ctrl_k[0] \_0626_ \_0659_ VSS VDD VDD \_0660_
+ sky130_fd_sc_hd__a21oi_1
* cell instance sky130_fd_sc_hd__a21oi_1_36 r0 *1 0,0
Xsky130_fd_sc_hd__a21oi_1_36 ctrl_k[4] \_0626_ \_0630_ VSS VDD VDD \_0631_
+ sky130_fd_sc_hd__a21oi_1
* cell instance sky130_fd_sc_hd__a21oi_1_37 r0 *1 0,0
Xsky130_fd_sc_hd__a21oi_1_37 \_0689_ \_0690_ net18 VSS VDD VDD \_0691_
+ sky130_fd_sc_hd__a21oi_1
* cell instance sky130_fd_sc_hd__a21oi_1_38 r0 *1 0,0
Xsky130_fd_sc_hd__a21oi_1_38 gate_cnt[24] \_0394_ gate_cnt[25] VSS VDD VDD
+ \_0401_ sky130_fd_sc_hd__a21oi_1
* cell instance sky130_fd_sc_hd__a21oi_1_39 r0 *1 0,0
Xsky130_fd_sc_hd__a21oi_1_39 \_0677_ \_0678_ net18 VSS VDD VDD \_0679_
+ sky130_fd_sc_hd__a21oi_1
* cell instance sky130_fd_sc_hd__a21oi_1_40 r0 *1 0,0
Xsky130_fd_sc_hd__a21oi_1_40 gate_cnt[24] \_0394_ net13 VSS VDD VDD \_0402_
+ sky130_fd_sc_hd__a21oi_1
* cell instance sky130_fd_sc_hd__a21oi_1_41 r0 *1 0,0
Xsky130_fd_sc_hd__a21oi_1_41 gate_cnt[22] \_0403_ gate_cnt[23] VSS VDD VDD
+ \_0404_ sky130_fd_sc_hd__a21oi_1
* cell instance sky130_fd_sc_hd__a21oi_1_42 r0 *1 0,0
Xsky130_fd_sc_hd__a21oi_1_42 gate_cnt[22] \_0403_ net13 VSS VDD VDD \_0405_
+ sky130_fd_sc_hd__a21oi_1
* cell instance sky130_fd_sc_hd__a21oi_1_43 r0 *1 0,0
Xsky130_fd_sc_hd__a21oi_1_43 count_r[2][12] net22 \_0592_ VSS VDD VDD \_0593_
+ sky130_fd_sc_hd__a21oi_1
* cell instance sky130_fd_sc_hd__a21oi_1_44 r0 *1 0,0
Xsky130_fd_sc_hd__a21oi_1_44 count_r[2][22] net22 \_0488_ VSS VDD VDD \_0489_
+ sky130_fd_sc_hd__a21oi_1
* cell instance sky130_fd_sc_hd__a21oi_1_45 r0 *1 0,0
Xsky130_fd_sc_hd__a21oi_1_45 count_r[4][14] \_0479_ \_0580_ VSS VDD VDD \_0581_
+ sky130_fd_sc_hd__a21oi_1
* cell instance sky130_fd_sc_hd__a21oi_1_46 r0 *1 0,0
Xsky130_fd_sc_hd__a21oi_1_46 gate_cnt[19] \_0406_ gate_cnt[20] VSS VDD VDD
+ \_0409_ sky130_fd_sc_hd__a21oi_1
* cell instance sky130_fd_sc_hd__a21oi_1_47 r0 *1 0,0
Xsky130_fd_sc_hd__a21oi_1_47 count_r[1][10] net14 \_0612_ VSS VDD VDD \_0613_
+ sky130_fd_sc_hd__a21oi_1
* cell instance sky130_fd_sc_hd__a21oi_1_48 r0 *1 0,0
Xsky130_fd_sc_hd__a21oi_1_48 \_0668_ \_0669_ net18 VSS VDD VDD \_0670_
+ sky130_fd_sc_hd__a21oi_1
* cell instance sky130_fd_sc_hd__a21oi_1_49 r0 *1 0,0
Xsky130_fd_sc_hd__a21oi_1_49 \_0720_ \_0318_ \_0320_ VSS VDD VDD \_0000_
+ sky130_fd_sc_hd__a21oi_1
* cell instance sky130_fd_sc_hd__a21oi_1_50 r0 *1 0,0
Xsky130_fd_sc_hd__a21oi_1_50 gate_cnt[30] \_0381_ \_0383_ VSS VDD VDD \_0156_
+ sky130_fd_sc_hd__a21oi_1
* cell instance sky130_fd_sc_hd__a21oi_1_51 r0 *1 0,0
Xsky130_fd_sc_hd__a21oi_1_51 k_q[0] \_0705_ \_0721_ VSS VDD VDD \_0722_
+ sky130_fd_sc_hd__a21oi_1
* cell instance sky130_fd_sc_hd__a21oi_1_52 r0 *1 0,0
Xsky130_fd_sc_hd__a21oi_1_52 u_cnt/_080_ u_cnt/_105_ u_cnt/_106_ VSS VDD VDD
+ u_cnt/_006_ sky130_fd_sc_hd__a21oi_1
* cell instance sky130_fd_sc_hd__a21oi_1_53 r0 *1 0,0
Xsky130_fd_sc_hd__a21oi_1_53 u_cnt/_081_ u_cnt/_102_ u_cnt/_104_ VSS VDD VDD
+ u_cnt/_005_ sky130_fd_sc_hd__a21oi_1
* cell instance sky130_fd_sc_hd__a21oi_1_54 r0 *1 0,0
Xsky130_fd_sc_hd__a21oi_1_54 count_r[2][15] net21 \_0572_ VSS VDD VDD \_0573_
+ sky130_fd_sc_hd__a21oi_1
* cell instance sky130_fd_sc_hd__a21oi_1_55 r0 *1 0,0
Xsky130_fd_sc_hd__a21oi_1_55 cnt_o[20] u_cnt/_026_ u_cnt/_027_ VSS VDD VDD
+ u_cnt/_007_ sky130_fd_sc_hd__a21oi_1
* cell instance sky130_fd_sc_hd__a21oi_1_56 r0 *1 0,0
Xsky130_fd_sc_hd__a21oi_1_56 u_cnt/_034_ u_cnt/_035_ u_cnt/_031_ VSS VDD VDD
+ u_cnt/_010_ sky130_fd_sc_hd__a21oi_1
* cell instance sky130_fd_sc_hd__a21oi_1_57 r0 *1 0,0
Xsky130_fd_sc_hd__a21oi_1_57 u_cnt/_031_ u_cnt/_032_ u_cnt/_033_ VSS VDD VDD
+ u_cnt/_009_ sky130_fd_sc_hd__a21oi_1
* cell instance sky130_fd_sc_hd__a21oi_1_58 r0 *1 0,0
Xsky130_fd_sc_hd__a21oi_1_58 u_cnt/_028_ u_cnt/_029_ u_cnt/_026_ VSS VDD VDD
+ u_cnt/_008_ sky130_fd_sc_hd__a21oi_1
* cell instance sky130_fd_sc_hd__a21oi_1_59 r0 *1 0,0
Xsky130_fd_sc_hd__a21oi_1_59 \_0728_ \_0730_ gate_cnt[5] VSS VDD VDD \_0731_
+ sky130_fd_sc_hd__a21oi_1
* cell instance sky130_fd_sc_hd__a21oi_1_60 r0 *1 0,0
Xsky130_fd_sc_hd__a21oi_1_60 u_cnt/_045_ u_cnt/_103_ u_cnt/_088_ VSS VDD VDD
+ u_cnt/_016_ sky130_fd_sc_hd__a21oi_1
* cell instance sky130_fd_sc_hd__a21oi_1_61 r0 *1 0,0
Xsky130_fd_sc_hd__a21oi_1_61 gate_cnt[0] gate_en gate_cnt[1] VSS VDD VDD
+ \_0438_ sky130_fd_sc_hd__a21oi_1
* cell instance sky130_fd_sc_hd__a21oi_1_62 r0 *1 0,0
Xsky130_fd_sc_hd__a21oi_1_62 \_0741_ \_0293_ gate_cnt[0] VSS VDD VDD \_0309_
+ sky130_fd_sc_hd__a21oi_1
* cell instance sky130_fd_sc_hd__a21oi_1_63 r0 *1 0,0
Xsky130_fd_sc_hd__a21oi_1_63 \_0635_ \_0636_ net18 VSS VDD VDD \_0637_
+ sky130_fd_sc_hd__a21oi_1
* cell instance sky130_fd_sc_hd__a21oi_1_64 r0 *1 0,0
Xsky130_fd_sc_hd__a21oi_1_64 count_r[2][19] net21 \_0531_ VSS VDD VDD \_0532_
+ sky130_fd_sc_hd__a21oi_1
* cell instance sky130_fd_sc_hd__a21oi_1_65 r0 *1 0,0
Xsky130_fd_sc_hd__a21oi_1_65 u_cnt/_061_ u_cnt/_062_ u_cnt/_063_ VSS VDD VDD
+ u_cnt/_022_ sky130_fd_sc_hd__a21oi_1
* cell instance sky130_fd_sc_hd__a21oi_1_66 r0 *1 0,0
Xsky130_fd_sc_hd__a21oi_1_66 gate_cnt[15] \_0392_ gate_cnt[16] VSS VDD VDD
+ \_0414_ sky130_fd_sc_hd__a21oi_1
* cell instance sky130_fd_sc_hd__a21oi_1_67 r0 *1 0,0
Xsky130_fd_sc_hd__a21oi_1_67 u_cnt/_071_ u_cnt/_064_ u_cnt/_061_ VSS VDD VDD
+ u_cnt/_023_ sky130_fd_sc_hd__a21oi_1
* cell instance sky130_fd_sc_hd__a21oi_1_68 r0 *1 0,0
Xsky130_fd_sc_hd__a21oi_1_68 k_q[3] \_0745_ k_q[4] VSS VDD VDD \_0746_
+ sky130_fd_sc_hd__a21oi_1
* cell instance sky130_fd_sc_hd__a21oi_1_69 r0 *1 0,0
Xsky130_fd_sc_hd__a21oi_1_69 u_cnt/_078_ u_cnt/_084_ u_cnt/_088_ VSS VDD VDD
+ u_cnt/_039_ sky130_fd_sc_hd__a21oi_1
* cell instance sky130_fd_sc_hd__a21oi_1_70 r0 *1 0,0
Xsky130_fd_sc_hd__a21oi_1_70 k_q[3] k_q[2] k_q[4] VSS VDD VDD \_0695_
+ sky130_fd_sc_hd__a21oi_1
* cell instance sky130_fd_sc_hd__a21oi_1_71 r0 *1 0,0
Xsky130_fd_sc_hd__a21oi_1_71 \_0638_ \_0639_ net18 VSS VDD VDD \_0640_
+ sky130_fd_sc_hd__a21oi_1
* cell instance sky130_fd_sc_hd__a21oi_1_72 r0 *1 0,0
Xsky130_fd_sc_hd__a21oi_1_72 k_q[3] \_0705_ k_q[4] VSS VDD VDD \_0708_
+ sky130_fd_sc_hd__a21oi_1
* cell instance sky130_fd_sc_hd__a21oi_1_73 r0 *1 0,0
Xsky130_fd_sc_hd__a21oi_1_73 count_r[4][23] \_0479_ \_0327_ VSS VDD VDD \_0328_
+ sky130_fd_sc_hd__a21oi_1
* cell instance sky130_fd_sc_hd__a21oi_1_74 r0 *1 0,0
Xsky130_fd_sc_hd__a21oi_1_74 u_cnt/_052_ u_cnt/_053_ u_cnt/_050_ VSS VDD VDD
+ u_cnt/_019_ sky130_fd_sc_hd__a21oi_1
* cell instance sky130_fd_sc_hd__a21oi_1_75 r0 *1 0,0
Xsky130_fd_sc_hd__a21oi_1_75 u_cnt/_057_ u_cnt/_058_ u_cnt/_054_ VSS VDD VDD
+ u_cnt/_021_ sky130_fd_sc_hd__a21oi_1
* cell instance sky130_fd_sc_hd__a21oi_1_76 r0 *1 0,0
Xsky130_fd_sc_hd__a21oi_1_76 u_cnt/_047_ u_cnt/_084_ cnt_o[9] VSS VDD VDD
+ u_cnt/_056_ sky130_fd_sc_hd__a21oi_1
* cell instance sky130_fd_sc_hd__a21oi_1_77 r0 *1 0,0
Xsky130_fd_sc_hd__a21oi_1_77 u_cnt/_054_ u_cnt/_055_ u_cnt/_056_ VSS VDD VDD
+ u_cnt/_020_ sky130_fd_sc_hd__a21oi_1
* cell instance sky130_fd_sc_hd__a21oi_1_78 r0 *1 0,0
Xsky130_fd_sc_hd__a21oi_1_78 gate_cnt[7] \_0428_ \_0430_ VSS VDD VDD \_0179_
+ sky130_fd_sc_hd__a21oi_1
* cell instance sky130_fd_sc_hd__a21oi_1_79 r0 *1 0,0
Xsky130_fd_sc_hd__a21oi_1_79 cnt_o[11] u_cnt/_050_ u_cnt/_051_ VSS VDD VDD
+ u_cnt/_018_ sky130_fd_sc_hd__a21oi_1
* cell instance sky130_fd_sc_hd__a21oi_1_80 r0 *1 0,0
Xsky130_fd_sc_hd__a21oi_1_80 gate_cnt[7] \_0428_ gate_cnt[8] VSS VDD VDD
+ \_0429_ sky130_fd_sc_hd__a21oi_1
* cell instance sky130_fd_sc_hd__a21oi_1_81 r0 *1 0,0
Xsky130_fd_sc_hd__a21oi_1_81 u_cnt/_037_ u_cnt/_084_ u_cnt/_088_ VSS VDD VDD
+ u_cnt/_043_ sky130_fd_sc_hd__a21oi_1
* cell instance sky130_fd_sc_hd__a21oi_1_82 r0 *1 0,0
Xsky130_fd_sc_hd__a21oi_1_82 \_0664_ \_0665_ net18 VSS VDD VDD \_0666_
+ sky130_fd_sc_hd__a21oi_1
* cell instance sky130_fd_sc_hd__a21oi_1_83 r0 *1 0,0
Xsky130_fd_sc_hd__a21oi_1_83 u_cnt/_068_ u_cnt/_084_ cnt_o[3] VSS VDD VDD
+ u_cnt/_093_ sky130_fd_sc_hd__a21oi_1
* cell instance sky130_fd_sc_hd__a21oi_1_84 r0 *1 0,0
Xsky130_fd_sc_hd__a21oi_1_84 gate_cnt[4] \_0432_ gate_cnt[5] VSS VDD VDD
+ \_0433_ sky130_fd_sc_hd__a21oi_1
* cell instance sky130_fd_sc_hd__a21oi_1_85 r0 *1 0,0
Xsky130_fd_sc_hd__a21oi_1_85 count_r[1][9] net14 \_0620_ VSS VDD VDD \_0621_
+ sky130_fd_sc_hd__a21oi_1
* cell instance sky130_fd_sc_hd__a21oi_1_86 r0 *1 0,0
Xsky130_fd_sc_hd__a21oi_1_86 gate_cnt[4] \_0432_ \_0434_ VSS VDD VDD \_0182_
+ sky130_fd_sc_hd__a21oi_1
* cell instance sky130_fd_sc_hd__a21oi_1_87 r0 *1 0,0
Xsky130_fd_sc_hd__a21oi_1_87 gate_cnt[15] \_0418_ \_0419_ VSS VDD VDD \_0171_
+ sky130_fd_sc_hd__a21oi_1
* cell instance sky130_fd_sc_hd__a21oi_1_88 r0 *1 0,0
Xsky130_fd_sc_hd__a21oi_1_88 count_r[3][13] net16 \_0584_ VSS VDD VDD \_0585_
+ sky130_fd_sc_hd__a21oi_1
* cell instance sky130_fd_sc_hd__a21oi_1_89 r0 *1 0,0
Xsky130_fd_sc_hd__a21oi_1_89 count_r[3][11] net16 \_0600_ VSS VDD VDD \_0601_
+ sky130_fd_sc_hd__a21oi_1
* cell instance sky130_fd_sc_hd__a21oi_1_90 r0 *1 0,0
Xsky130_fd_sc_hd__a21oi_1_90 \_0650_ \_0651_ net18 VSS VDD VDD \_0652_
+ sky130_fd_sc_hd__a21oi_1
* cell instance sky130_fd_sc_hd__a21oi_1_91 r0 *1 0,0
Xsky130_fd_sc_hd__a21oi_1_91 gate_cnt[12] \_0422_ gate_cnt[13] VSS VDD VDD
+ \_0423_ sky130_fd_sc_hd__a21oi_1
* cell instance sky130_fd_sc_hd__a21oi_1_92 r0 *1 0,0
Xsky130_fd_sc_hd__a21oi_1_92 \_0627_ \_0629_ net18 VSS VDD VDD \_0630_
+ sky130_fd_sc_hd__a21oi_1
* cell instance sky130_fd_sc_hd__a21oi_1_93 r0 *1 0,0
Xsky130_fd_sc_hd__a21oi_1_93 \_0657_ \_0658_ net18 VSS VDD VDD \_0659_
+ sky130_fd_sc_hd__a21oi_1
* cell instance sky130_fd_sc_hd__a21oi_1_94 r0 *1 0,0
Xsky130_fd_sc_hd__a21oi_1_94 gate_cnt[12] \_0422_ \_0424_ VSS VDD VDD \_0174_
+ sky130_fd_sc_hd__a21oi_1
* cell instance sky130_fd_sc_hd__a221o_1_0 r0 *1 0,0
Xsky130_fd_sc_hd__a221o_1_0 busy_r \_0667_ \_0688_ \_0648_ \_0691_ VSS VDD VDD
+ rdata[0] sky130_fd_sc_hd__a221o_1
* cell instance sky130_fd_sc_hd__a221o_1_1 r0 *1 0,0
Xsky130_fd_sc_hd__a221o_1_1 ctrl_k[1] \_0626_ \_0647_ \_0648_ \_0652_ VSS VDD
+ VDD rdata[5] sky130_fd_sc_hd__a221o_1
* cell instance sky130_fd_sc_hd__a221oi_1_0 r0 *1 0,0
Xsky130_fd_sc_hd__a221oi_1_0 gate_cnt[18] \_0301_ \_0302_ gate_cnt[20] \_0304_
+ VSS VDD VDD \_0305_ sky130_fd_sc_hd__a221oi_1
* cell instance sky130_fd_sc_hd__a221oi_1_1 r0 *1 0,0
Xsky130_fd_sc_hd__a221oi_1_1 u_cnt/_036_ u_cnt/_084_ u_cnt/_049_ u_cnt/_070_
+ u_cnt/_088_ VSS VDD VDD u_cnt/_017_ sky130_fd_sc_hd__a221oi_1
* cell instance sky130_fd_sc_hd__a222oi_1_0 r0 *1 0,0
Xsky130_fd_sc_hd__a222oi_1_0 cal_r[3][19] net15 net20 cal_r[1][19] cal_r[4][19]
+ net22 VSS VDD VDD \_0537_ sky130_fd_sc_hd__a222oi_1
* cell instance sky130_fd_sc_hd__a222oi_1_1 r0 *1 0,0
Xsky130_fd_sc_hd__a222oi_1_1 cal_r[3][12] net15 \_0500_ cal_r[2][12] \_0493_
+ cal_r[1][12] VSS VDD VDD \_0595_ sky130_fd_sc_hd__a222oi_1
* cell instance sky130_fd_sc_hd__a222oi_1_2 r0 *1 0,0
Xsky130_fd_sc_hd__a222oi_1_2 cal_r[4][15] net22 net15 cal_r[3][15] cal_r[2][15]
+ net19 VSS VDD VDD \_0567_ sky130_fd_sc_hd__a222oi_1
* cell instance sky130_fd_sc_hd__a222oi_1_3 r0 *1 0,0
Xsky130_fd_sc_hd__a222oi_1_3 cal_r[3][23] net15 \_0493_ cal_r[1][23] \_0500_
+ cal_r[2][23] VSS VDD VDD \_0322_ sky130_fd_sc_hd__a222oi_1
* cell instance sky130_fd_sc_hd__a222oi_1_4 r0 *1 0,0
Xsky130_fd_sc_hd__a222oi_1_4 cal_r[3][17] net15 net19 cal_r[2][17] net20
+ cal_r[1][17] VSS VDD VDD \_0550_ sky130_fd_sc_hd__a222oi_1
* cell instance sky130_fd_sc_hd__a222oi_1_5 r0 *1 0,0
Xsky130_fd_sc_hd__a222oi_1_5 cal_r[4][22] net22 net19 cal_r[2][22] net15
+ cal_r[3][22] VSS VDD VDD \_0504_ sky130_fd_sc_hd__a222oi_1
* cell instance sky130_fd_sc_hd__a222oi_1_6 r0 *1 0,0
Xsky130_fd_sc_hd__a222oi_1_6 cal_r[4][0] net22 net19 cal_r[2][0] cal_r[1][0]
+ net20 VSS VDD VDD \_0687_ sky130_fd_sc_hd__a222oi_1
* cell instance sky130_fd_sc_hd__a222oi_1_7 r0 *1 0,0
Xsky130_fd_sc_hd__a222oi_1_7 cal_r[4][13] net21 net15 cal_r[3][13] \_0493_
+ cal_r[1][13] VSS VDD VDD \_0587_ sky130_fd_sc_hd__a222oi_1
* cell instance sky130_fd_sc_hd__a222oi_1_8 r0 *1 0,0
Xsky130_fd_sc_hd__a222oi_1_8 cal_r[4][20] net21 \_0500_ cal_r[2][20] net15
+ cal_r[3][20] VSS VDD VDD \_0525_ sky130_fd_sc_hd__a222oi_1
* cell instance sky130_fd_sc_hd__a222oi_1_9 r0 *1 0,0
Xsky130_fd_sc_hd__a222oi_1_9 cal_r[4][1] net22 net20 cal_r[1][1] net19
+ cal_r[2][1] VSS VDD VDD \_0682_ sky130_fd_sc_hd__a222oi_1
* cell instance sky130_fd_sc_hd__a222oi_1_10 r0 *1 0,0
Xsky130_fd_sc_hd__a222oi_1_10 cal_r[4][18] net22 net20 cal_r[1][18] net19
+ cal_r[2][18] VSS VDD VDD \_0541_ sky130_fd_sc_hd__a222oi_1
* cell instance sky130_fd_sc_hd__a222oi_1_11 r0 *1 0,0
Xsky130_fd_sc_hd__a222oi_1_11 cal_r[4][10] net22 net15 cal_r[3][10] net20
+ cal_r[1][10] VSS VDD VDD \_0607_ sky130_fd_sc_hd__a222oi_1
* cell instance sky130_fd_sc_hd__a222oi_1_12 r0 *1 0,0
Xsky130_fd_sc_hd__a222oi_1_12 cal_r[4][14] net21 net15 cal_r[3][14] \_0500_
+ cal_r[2][14] VSS VDD VDD \_0575_ sky130_fd_sc_hd__a222oi_1
* cell instance sky130_fd_sc_hd__a222oi_1_13 r0 *1 0,0
Xsky130_fd_sc_hd__a222oi_1_13 cal_r[4][2] net22 net19 cal_r[2][2] cal_r[1][2]
+ net20 VSS VDD VDD \_0674_ sky130_fd_sc_hd__a222oi_1
* cell instance sky130_fd_sc_hd__a222oi_1_14 r0 *1 0,0
Xsky130_fd_sc_hd__a222oi_1_14 cal_r[4][4] net22 net14 cal_r[3][4] net19
+ cal_r[2][4] VSS VDD VDD \_0654_ sky130_fd_sc_hd__a222oi_1
* cell instance sky130_fd_sc_hd__a222oi_1_15 r0 *1 0,0
Xsky130_fd_sc_hd__a222oi_1_15 cal_r[4][16] net21 \_0500_ cal_r[2][16] net15
+ cal_r[3][16] VSS VDD VDD \_0562_ sky130_fd_sc_hd__a222oi_1
* cell instance sky130_fd_sc_hd__a222oi_1_16 r0 *1 0,0
Xsky130_fd_sc_hd__a222oi_1_16 cal_r[4][21] net21 \_0500_ cal_r[2][21] net15
+ cal_r[3][21] VSS VDD VDD \_0516_ sky130_fd_sc_hd__a222oi_1
* cell instance sky130_fd_sc_hd__a222oi_1_17 r0 *1 0,0
Xsky130_fd_sc_hd__a222oi_1_17 cal_r[4][11] net22 net14 cal_r[3][11] net19
+ cal_r[2][11] VSS VDD VDD \_0603_ sky130_fd_sc_hd__a222oi_1
* cell instance sky130_fd_sc_hd__a222oi_1_18 r0 *1 0,0
Xsky130_fd_sc_hd__a222oi_1_18 cal_r[3][9] net15 \_0500_ cal_r[2][9] cal_r[4][9]
+ net21 VSS VDD VDD \_0615_ sky130_fd_sc_hd__a222oi_1
* cell instance sky130_fd_sc_hd__a222oi_1_19 r0 *1 0,0
Xsky130_fd_sc_hd__a222oi_1_19 cal_r[4][5] net22 net15 cal_r[3][5] net20
+ cal_r[1][5] VSS VDD VDD \_0646_ sky130_fd_sc_hd__a222oi_1
* cell instance sky130_fd_sc_hd__a222oi_1_20 r0 *1 0,0
Xsky130_fd_sc_hd__a222oi_1_20 cal_r[2][7] net19 net20 cal_r[1][7] cal_r[3][7]
+ net14 VSS VDD VDD \_0633_ sky130_fd_sc_hd__a222oi_1
* cell instance sky130_fd_sc_hd__a222oi_1_21 r0 *1 0,0
Xsky130_fd_sc_hd__a222oi_1_21 cal_r[3][8] net14 net20 cal_r[1][8] net19
+ cal_r[2][8] VSS VDD VDD \_0623_ sky130_fd_sc_hd__a222oi_1
* cell instance sky130_fd_sc_hd__a222oi_1_22 r0 *1 0,0
Xsky130_fd_sc_hd__a222oi_1_22 cal_r[4][3] net22 net14 cal_r[3][3] net19
+ cal_r[2][3] VSS VDD VDD \_0662_ sky130_fd_sc_hd__a222oi_1
* cell instance sky130_fd_sc_hd__a222oi_1_23 r0 *1 0,0
Xsky130_fd_sc_hd__a222oi_1_23 cal_r[4][6] net22 net20 cal_r[1][6] net14
+ cal_r[3][6] VSS VDD VDD \_0642_ sky130_fd_sc_hd__a222oi_1
* cell instance sky130_fd_sc_hd__a222oi_1_24 r0 *1 0,0
Xsky130_fd_sc_hd__a222oi_1_24 count_r[4][16] \_0479_ net15 count_r[1][16] net16
+ count_r[3][16] VSS VDD VDD \_0558_ sky130_fd_sc_hd__a222oi_1
* cell instance sky130_fd_sc_hd__a222oi_1_25 r0 *1 0,0
Xsky130_fd_sc_hd__a222oi_1_25 count_r[2][17] net22 \_0479_ count_r[4][17]
+ count_r[3][17] net16 VSS VDD VDD \_0554_ sky130_fd_sc_hd__a222oi_1
* cell instance sky130_fd_sc_hd__a222oi_1_26 r0 *1 0,0
Xsky130_fd_sc_hd__a222oi_1_26 count_r[2][0] net22 \_0479_ count_r[4][0] net14
+ count_r[1][0] VSS VDD VDD \_0690_ sky130_fd_sc_hd__a222oi_1
* cell instance sky130_fd_sc_hd__a222oi_1_27 r0 *1 0,0
Xsky130_fd_sc_hd__a222oi_1_27 count_r[2][20] net21 net16 count_r[3][20] \_0479_
+ count_r[4][20] VSS VDD VDD \_0521_ sky130_fd_sc_hd__a222oi_1
* cell instance sky130_fd_sc_hd__a222oi_1_28 r0 *1 0,0
Xsky130_fd_sc_hd__a222oi_1_28 count_r[2][21] net22 \_0479_ count_r[4][21] net16
+ count_r[3][21] VSS VDD VDD \_0511_ sky130_fd_sc_hd__a222oi_1
* cell instance sky130_fd_sc_hd__a222oi_1_29 r0 *1 0,0
Xsky130_fd_sc_hd__a222oi_1_29 count_r[2][18] net21 \_0479_ count_r[4][18] net15
+ count_r[1][18] VSS VDD VDD \_0545_ sky130_fd_sc_hd__a222oi_1
* cell instance sky130_fd_sc_hd__a222oi_1_30 r0 *1 0,0
Xsky130_fd_sc_hd__a222oi_1_30 count_r[0][1] \_0628_ net22 count_r[2][1] \_0479_
+ count_r[4][1] VSS VDD VDD \_0678_ sky130_fd_sc_hd__a222oi_1
* cell instance sky130_fd_sc_hd__a222oi_1_31 r0 *1 0,0
Xsky130_fd_sc_hd__a222oi_1_31 count_r[2][10] net22 \_0479_ count_r[4][10] net16
+ count_r[3][10] VSS VDD VDD \_0611_ sky130_fd_sc_hd__a222oi_1
* cell instance sky130_fd_sc_hd__a222oi_1_32 r0 *1 0,0
Xsky130_fd_sc_hd__a222oi_1_32 count_r[4][22] \_0479_ net16 count_r[3][22]
+ count_r[1][22] net14 VSS VDD VDD \_0487_ sky130_fd_sc_hd__a222oi_1
* cell instance sky130_fd_sc_hd__a222oi_1_33 r0 *1 0,0
Xsky130_fd_sc_hd__a222oi_1_33 count_r[4][12] \_0479_ net16 count_r[3][12] net14
+ count_r[1][12] VSS VDD VDD \_0591_ sky130_fd_sc_hd__a222oi_1
* cell instance sky130_fd_sc_hd__a222oi_1_34 r0 *1 0,0
Xsky130_fd_sc_hd__a222oi_1_34 count_r[2][14] net21 net15 count_r[1][14] net16
+ count_r[3][14] VSS VDD VDD \_0579_ sky130_fd_sc_hd__a222oi_1
* cell instance sky130_fd_sc_hd__a222oi_1_35 r0 *1 0,0
Xsky130_fd_sc_hd__a222oi_1_35 count_r[2][2] net22 net16 count_r[3][2] net14
+ count_r[1][2] VSS VDD VDD \_0669_ sky130_fd_sc_hd__a222oi_1
* cell instance sky130_fd_sc_hd__a222oi_1_36 r0 *1 0,0
Xsky130_fd_sc_hd__a222oi_1_36 count_r[4][15] \_0479_ net16 count_r[3][15] net15
+ count_r[1][15] VSS VDD VDD \_0571_ sky130_fd_sc_hd__a222oi_1
* cell instance sky130_fd_sc_hd__a222oi_1_37 r0 *1 0,0
Xsky130_fd_sc_hd__a222oi_1_37 count_r[4][19] \_0479_ net16 count_r[3][19]
+ count_r[1][19] net15 VSS VDD VDD \_0530_ sky130_fd_sc_hd__a222oi_1
* cell instance sky130_fd_sc_hd__a222oi_1_38 r0 *1 0,0
Xsky130_fd_sc_hd__a222oi_1_38 count_r[0][7] \_0628_ \_0479_ count_r[4][7] net16
+ count_r[3][7] VSS VDD VDD \_0636_ sky130_fd_sc_hd__a222oi_1
* cell instance sky130_fd_sc_hd__a222oi_1_39 r0 *1 0,0
Xsky130_fd_sc_hd__a222oi_1_39 count_r[2][6] net22 net14 count_r[1][6] net16
+ count_r[3][6] VSS VDD VDD \_0639_ sky130_fd_sc_hd__a222oi_1
* cell instance sky130_fd_sc_hd__a222oi_1_40 r0 *1 0,0
Xsky130_fd_sc_hd__a222oi_1_40 count_r[0][3] \_0628_ net16 count_r[3][3] net14
+ count_r[1][3] VSS VDD VDD \_0665_ sky130_fd_sc_hd__a222oi_1
* cell instance sky130_fd_sc_hd__a222oi_1_41 r0 *1 0,0
Xsky130_fd_sc_hd__a222oi_1_41 count_r[2][23] net21 net16 count_r[3][23] net14
+ count_r[1][23] VSS VDD VDD \_0326_ sky130_fd_sc_hd__a222oi_1
* cell instance sky130_fd_sc_hd__a222oi_1_42 r0 *1 0,0
Xsky130_fd_sc_hd__a222oi_1_42 count_r[2][9] net21 \_0479_ count_r[4][9] net16
+ count_r[3][9] VSS VDD VDD \_0619_ sky130_fd_sc_hd__a222oi_1
* cell instance sky130_fd_sc_hd__a222oi_1_43 r0 *1 0,0
Xsky130_fd_sc_hd__a222oi_1_43 count_r[0][8] \_0628_ \_0479_ count_r[4][8] net16
+ count_r[3][8] VSS VDD VDD \_0629_ sky130_fd_sc_hd__a222oi_1
* cell instance sky130_fd_sc_hd__a222oi_1_44 r0 *1 0,0
Xsky130_fd_sc_hd__a222oi_1_44 count_r[0][4] \_0628_ \_0479_ count_r[4][4] net16
+ count_r[3][4] VSS VDD VDD \_0658_ sky130_fd_sc_hd__a222oi_1
* cell instance sky130_fd_sc_hd__a222oi_1_45 r0 *1 0,0
Xsky130_fd_sc_hd__a222oi_1_45 count_r[2][13] net21 \_0479_ count_r[4][13] net14
+ count_r[1][13] VSS VDD VDD \_0583_ sky130_fd_sc_hd__a222oi_1
* cell instance sky130_fd_sc_hd__a222oi_1_46 r0 *1 0,0
Xsky130_fd_sc_hd__a222oi_1_46 count_r[2][11] net21 \_0479_ count_r[4][11]
+ count_r[1][11] net14 VSS VDD VDD \_0599_ sky130_fd_sc_hd__a222oi_1
* cell instance sky130_fd_sc_hd__a222oi_1_47 r0 *1 0,0
Xsky130_fd_sc_hd__a222oi_1_47 count_r[2][5] net22 \_0479_ count_r[4][5] net14
+ count_r[1][5] VSS VDD VDD \_0651_ sky130_fd_sc_hd__a222oi_1
* cell instance sky130_fd_sc_hd__a22oi_1_0 r0 *1 0,0
Xsky130_fd_sc_hd__a22oi_1_0 cal_r[3][1] net15 \_0496_ cal_r[0][1] VSS VDD VDD
+ \_0681_ sky130_fd_sc_hd__a22oi_1
* cell instance sky130_fd_sc_hd__a22oi_1_1 r0 *1 0,0
Xsky130_fd_sc_hd__a22oi_1_1 cal_r[0][3] \_0496_ net20 cal_r[1][3] VSS VDD VDD
+ \_0661_ sky130_fd_sc_hd__a22oi_1
* cell instance sky130_fd_sc_hd__a22oi_1_2 r0 *1 0,0
Xsky130_fd_sc_hd__a22oi_1_2 cal_r[0][6] \_0496_ net19 cal_r[2][6] VSS VDD VDD
+ \_0641_ sky130_fd_sc_hd__a22oi_1
* cell instance sky130_fd_sc_hd__a22oi_1_3 r0 *1 0,0
Xsky130_fd_sc_hd__a22oi_1_3 osc[0] \_0332_ \_0333_ osc[1] VSS VDD VDD \_0334_
+ sky130_fd_sc_hd__a22oi_1
* cell instance sky130_fd_sc_hd__a22oi_1_4 r0 *1 0,0
Xsky130_fd_sc_hd__a22oi_1_4 cal_r[4][7] net22 \_0496_ cal_r[0][7] VSS VDD VDD
+ \_0632_ sky130_fd_sc_hd__a22oi_1
* cell instance sky130_fd_sc_hd__a22oi_1_5 r0 *1 0,0
Xsky130_fd_sc_hd__a22oi_1_5 count_r[3][1] net16 net14 count_r[1][1] VSS VDD VDD
+ \_0677_ sky130_fd_sc_hd__a22oi_1
* cell instance sky130_fd_sc_hd__a22oi_1_6 r0 *1 0,0
Xsky130_fd_sc_hd__a22oi_1_6 count_r[0][0] \_0476_ net16 count_r[3][0] VSS VDD
+ VDD \_0689_ sky130_fd_sc_hd__a22oi_1
* cell instance sky130_fd_sc_hd__a22oi_1_7 r0 *1 0,0
Xsky130_fd_sc_hd__a22oi_1_7 count_r[0][2] \_0628_ \_0479_ count_r[4][2] VSS VDD
+ VDD \_0668_ sky130_fd_sc_hd__a22oi_1
* cell instance sky130_fd_sc_hd__a22oi_1_8 r0 *1 0,0
Xsky130_fd_sc_hd__a22oi_1_8 count_r[2][7] net22 net14 count_r[1][7] VSS VDD VDD
+ \_0635_ sky130_fd_sc_hd__a22oi_1
* cell instance sky130_fd_sc_hd__a22oi_1_9 r0 *1 0,0
Xsky130_fd_sc_hd__a22oi_1_9 gate_cnt[8] \_0746_ \_0740_ gate_cnt[25] VSS VDD
+ VDD \_0752_ sky130_fd_sc_hd__a22oi_1
* cell instance sky130_fd_sc_hd__a22oi_1_10 r0 *1 0,0
Xsky130_fd_sc_hd__a22oi_1_10 count_r[0][6] \_0476_ \_0479_ count_r[4][6] VSS
+ VDD VDD \_0638_ sky130_fd_sc_hd__a22oi_1
* cell instance sky130_fd_sc_hd__a22oi_1_11 r0 *1 0,0
Xsky130_fd_sc_hd__a22oi_1_11 count_r[2][3] net22 \_0479_ count_r[4][3] VSS VDD
+ VDD \_0664_ sky130_fd_sc_hd__a22oi_1
* cell instance sky130_fd_sc_hd__a22oi_1_12 r0 *1 0,0
Xsky130_fd_sc_hd__a22oi_1_12 count_r[0][5] net17 net16 count_r[3][5] VSS VDD
+ VDD \_0650_ sky130_fd_sc_hd__a22oi_1
* cell instance sky130_fd_sc_hd__a22oi_1_13 r0 *1 0,0
Xsky130_fd_sc_hd__a22oi_1_13 count_r[2][4] net22 net14 count_r[1][4] VSS VDD
+ VDD \_0657_ sky130_fd_sc_hd__a22oi_1
* cell instance sky130_fd_sc_hd__a22oi_1_14 r0 *1 0,0
Xsky130_fd_sc_hd__a22oi_1_14 count_r[2][8] net22 net14 count_r[1][8] VSS VDD
+ VDD \_0627_ sky130_fd_sc_hd__a22oi_1
* cell instance sky130_fd_sc_hd__a311oi_1_0 r0 *1 0,0
Xsky130_fd_sc_hd__a311oi_1_0 gate_cnt[6] \_0767_ \_0768_ \_0771_ \_0297_ VSS
+ VDD VDD \_0298_ sky130_fd_sc_hd__a311oi_1
* cell instance sky130_fd_sc_hd__a31o_1_0 r0 *1 0,0
Xsky130_fd_sc_hd__a31o_1_0 cnt_o[21] u_cnt/_101_ u_cnt/_084_ u_cnt/_088_ VSS
+ VDD VDD u_cnt/_106_ sky130_fd_sc_hd__a31o_1
* cell instance sky130_fd_sc_hd__a31oi_1_0 r0 *1 0,0
Xsky130_fd_sc_hd__a31oi_1_0 \_0468_ \_0466_ \_0467_ addr[3] VSS VDD VDD \_0469_
+ sky130_fd_sc_hd__a31oi_1
* cell instance sky130_fd_sc_hd__a31oi_1_1 r0 *1 0,0
Xsky130_fd_sc_hd__a31oi_1_1 \_0672_ \_0673_ \_0674_ \_0491_ VSS VDD VDD \_0675_
+ sky130_fd_sc_hd__a31oi_1
* cell instance sky130_fd_sc_hd__a31oi_1_2 r0 *1 0,0
Xsky130_fd_sc_hd__a31oi_1_2 gate_cnt[24] gate_cnt[25] \_0394_ gate_cnt[26] VSS
+ VDD VDD \_0399_ sky130_fd_sc_hd__a31oi_1
* cell instance sky130_fd_sc_hd__a31oi_1_3 r0 *1 0,0
Xsky130_fd_sc_hd__a31oi_1_3 gate_cnt[19] gate_cnt[20] \_0406_ gate_cnt[21] VSS
+ VDD VDD \_0407_ sky130_fd_sc_hd__a31oi_1
* cell instance sky130_fd_sc_hd__a31oi_1_4 r0 *1 0,0
Xsky130_fd_sc_hd__a31oi_1_4 cnt_o[1] cnt_o[0] u_cnt/_084_ u_cnt/_088_ VSS VDD
+ VDD u_cnt/_099_ sky130_fd_sc_hd__a31oi_1
* cell instance sky130_fd_sc_hd__a31oi_1_5 r0 *1 0,0
Xsky130_fd_sc_hd__a31oi_1_5 u_cnt/running u_cnt/_079_ u_cnt/_084_ cnt_o[20] VSS
+ VDD VDD u_cnt/_027_ sky130_fd_sc_hd__a31oi_1
* cell instance sky130_fd_sc_hd__a31oi_1_6 r0 *1 0,0
Xsky130_fd_sc_hd__a31oi_1_6 cnt_o[1] cnt_o[0] u_cnt/_084_ cnt_o[2] VSS VDD VDD
+ u_cnt/_094_ sky130_fd_sc_hd__a31oi_1
* cell instance sky130_fd_sc_hd__a31oi_1_7 r0 *1 0,0
Xsky130_fd_sc_hd__a31oi_1_7 cnt_o[17] u_cnt/_078_ u_cnt/_084_ cnt_o[18] VSS VDD
+ VDD u_cnt/_033_ sky130_fd_sc_hd__a31oi_1
* cell instance sky130_fd_sc_hd__a31oi_1_8 r0 *1 0,0
Xsky130_fd_sc_hd__a31oi_1_8 gate_cnt[5] \_0728_ \_0730_ \_0309_ VSS VDD VDD
+ \_0310_ sky130_fd_sc_hd__a31oi_1
* cell instance sky130_fd_sc_hd__a31oi_1_9 r0 *1 0,0
Xsky130_fd_sc_hd__a31oi_1_9 \_0370_ \_0374_ \_0379_ gate_cnt[28] VSS VDD VDD
+ \_0385_ sky130_fd_sc_hd__a31oi_1
* cell instance sky130_fd_sc_hd__a31oi_1_10 r0 *1 0,0
Xsky130_fd_sc_hd__a31oi_1_10 cnt_o[6] u_cnt/_059_ u_cnt/_084_ cnt_o[7] VSS VDD
+ VDD u_cnt/_063_ sky130_fd_sc_hd__a31oi_1
* cell instance sky130_fd_sc_hd__a31oi_1_11 r0 *1 0,0
Xsky130_fd_sc_hd__a31oi_1_11 k_q[3] k_q[0] \_0705_ k_q[4] VSS VDD VDD \_0738_
+ sky130_fd_sc_hd__a31oi_1
* cell instance sky130_fd_sc_hd__a31oi_1_12 r0 *1 0,0
Xsky130_fd_sc_hd__a31oi_1_12 u_cnt/running u_cnt/_048_ u_cnt/_084_ cnt_o[11]
+ VSS VDD VDD u_cnt/_051_ sky130_fd_sc_hd__a31oi_1
* cell instance sky130_fd_sc_hd__a32oi_1_0 r0 *1 0,0
Xsky130_fd_sc_hd__a32oi_1_0 gate_cnt[0] gate_cnt[15] k_q[4] \_0294_ \_0296_ VSS
+ VDD VDD \_0297_ sky130_fd_sc_hd__a32oi_1
* cell instance sky130_fd_sc_hd__a32oi_1_1 r0 *1 0,0
Xsky130_fd_sc_hd__a32oi_1_1 u_cnt/running u_cnt/_036_ u_cnt/_084_ u_cnt/_095_
+ cnt_o[13] VSS VDD VDD u_cnt/_044_ sky130_fd_sc_hd__a32oi_1
* cell instance sky130_fd_sc_hd__a41o_1_0 r0 *1 0,0
Xsky130_fd_sc_hd__a41o_1_0 cnt_o[20] cnt_o[23] u_cnt/_079_ u_cnt/_082_
+ u_cnt/_083_ VSS VDD VDD u_cnt/_096_ sky130_fd_sc_hd__a41o_1
* cell instance sky130_fd_sc_hd__a41o_1_1 r0 *1 0,0
Xsky130_fd_sc_hd__a41o_1_1 cnt_o[3] cnt_o[4] u_cnt/_068_ u_cnt/_084_ cnt_o[5]
+ VSS VDD VDD u_cnt/_066_ sky130_fd_sc_hd__a41o_1
* cell instance sky130_fd_sc_hd__a41oi_1_0 r0 *1 0,0
Xsky130_fd_sc_hd__a41oi_1_0 cnt_o[23] u_cnt/gate_s2 u_cnt/_101_ u_cnt/_082_
+ ovf_o VSS VDD VDD u_cnt/_067_ sky130_fd_sc_hd__a41oi_1
* cell instance sky130_fd_sc_hd__a41oi_1_1 r0 *1 0,0
Xsky130_fd_sc_hd__a41oi_1_1 cnt_o[13] cnt_o[14] u_cnt/_036_ u_cnt/_084_
+ cnt_o[15] VSS VDD VDD u_cnt/_040_ sky130_fd_sc_hd__a41oi_1
* cell instance sky130_fd_sc_hd__a41oi_2_0 r0 *1 0,0
Xsky130_fd_sc_hd__a41oi_2_0 gate_cnt[24] gate_cnt[25] gate_cnt[26] \_0394_
+ gate_cnt[27] VSS VDD VDD \_0397_ sky130_fd_sc_hd__a41oi_2
* cell instance sky130_fd_sc_hd__a41oi_2_1 r0 *1 0,0
Xsky130_fd_sc_hd__a41oi_2_1 cnt_o[20] cnt_o[23] u_cnt/_079_ u_cnt/_082_
+ u_cnt/_083_ VSS VDD VDD u_cnt/_084_ sky130_fd_sc_hd__a41oi_2
* cell instance sky130_fd_sc_hd__a41oi_2_2 r0 *1 0,0
Xsky130_fd_sc_hd__a41oi_2_2 cnt_o[3] cnt_o[4] u_cnt/_068_ u_cnt/_084_
+ u_cnt/_088_ VSS VDD VDD u_cnt/_090_ sky130_fd_sc_hd__a41oi_2
* cell instance sky130_fd_sc_hd__and2_1_0 r0 *1 0,0
Xsky130_fd_sc_hd__and2_1_0 addr[3] \_0490_ VSS VDD VDD \_0648_
+ sky130_fd_sc_hd__and2_1
* cell instance sky130_fd_sc_hd__and2_1_1 r0 *1 0,0
Xsky130_fd_sc_hd__and2_1_1 gate_cnt[18] \_0393_ VSS VDD VDD \_0406_
+ sky130_fd_sc_hd__and2_1
* cell instance sky130_fd_sc_hd__and2_1_2 r0 *1 0,0
Xsky130_fd_sc_hd__and2_1_2 k_q[2] k_q[1] VSS VDD VDD \_0705_
+ sky130_fd_sc_hd__and2_1
* cell instance sky130_fd_sc_hd__and2_1_3 r0 *1 0,0
Xsky130_fd_sc_hd__and2_1_3 cnt_o[20] u_cnt/_079_ VSS VDD VDD u_cnt/_101_
+ sky130_fd_sc_hd__and2_1
* cell instance sky130_fd_sc_hd__and2_1_4 r0 *1 0,0
Xsky130_fd_sc_hd__and2_1_4 gate_cnt[9] \_0415_ VSS VDD VDD \_0416_
+ sky130_fd_sc_hd__and2_1
* cell instance sky130_fd_sc_hd__and2_1_5 r0 *1 0,0
Xsky130_fd_sc_hd__and2_1_5 gate_cnt[14] \_0417_ VSS VDD VDD \_0418_
+ sky130_fd_sc_hd__and2_1
* cell instance sky130_fd_sc_hd__and2_1_6 r0 *1 0,0
Xsky130_fd_sc_hd__and2_1_6 gate_cnt[11] \_0421_ VSS VDD VDD \_0422_
+ sky130_fd_sc_hd__and2_1
* cell instance sky130_fd_sc_hd__and2_2_0 r0 *1 0,0
Xsky130_fd_sc_hd__and2_2_0 \_0388_ \_0393_ VSS VDD VDD \_0403_
+ sky130_fd_sc_hd__and2_2
* cell instance sky130_fd_sc_hd__and2_2_1 r0 *1 0,0
Xsky130_fd_sc_hd__and2_2_1 gate_cnt[3] \_0390_ VSS VDD VDD \_0432_
+ sky130_fd_sc_hd__and2_2
* cell instance sky130_fd_sc_hd__and2_2_2 r0 *1 0,0
Xsky130_fd_sc_hd__and2_2_2 gate_cnt[6] \_0391_ VSS VDD VDD \_0428_
+ sky130_fd_sc_hd__and2_2
* cell instance sky130_fd_sc_hd__and2_2_3 r0 *1 0,0
Xsky130_fd_sc_hd__and2_2_3 gate_cnt[7] gate_cnt[8] VSS VDD VDD \_0389_
+ sky130_fd_sc_hd__and2_2
* cell instance sky130_fd_sc_hd__and3_1_0 r0 *1 0,0
Xsky130_fd_sc_hd__and3_1_0 gate_cnt[19] gate_cnt[20] \_0406_ VSS VDD VDD
+ \_0408_ sky130_fd_sc_hd__and3_1
* cell instance sky130_fd_sc_hd__and3_1_1 r0 *1 0,0
Xsky130_fd_sc_hd__and3_1_1 cnt_o[1] cnt_o[0] cnt_o[2] VSS VDD VDD u_cnt/_068_
+ sky130_fd_sc_hd__and3_1
* cell instance sky130_fd_sc_hd__and3_1_2 r0 *1 0,0
Xsky130_fd_sc_hd__and3_1_2 cnt_o[9] cnt_o[10] u_cnt/_047_ VSS VDD VDD
+ u_cnt/_048_ sky130_fd_sc_hd__and3_1
* cell instance sky130_fd_sc_hd__and3_1_3 r0 *1 0,0
Xsky130_fd_sc_hd__and3_1_3 cnt_o[13] cnt_o[14] u_cnt/_036_ VSS VDD VDD
+ u_cnt/_037_ sky130_fd_sc_hd__and3_1
* cell instance sky130_fd_sc_hd__and3_1_4 r0 *1 0,0
Xsky130_fd_sc_hd__and3_1_4 gate_cnt[9] gate_cnt[10] \_0415_ VSS VDD VDD \_0421_
+ sky130_fd_sc_hd__and3_1
* cell instance sky130_fd_sc_hd__and3_2_0 r0 *1 0,0
Xsky130_fd_sc_hd__and3_2_0 gate_cnt[24] gate_cnt[25] \_0394_ VSS VDD VDD
+ \_0396_ sky130_fd_sc_hd__and3_2
* cell instance sky130_fd_sc_hd__and3_2_1 r0 *1 0,0
Xsky130_fd_sc_hd__and3_2_1 gate_cnt[1] gate_cnt[0] gate_en VSS VDD VDD \_0436_
+ sky130_fd_sc_hd__and3_2
* cell instance sky130_fd_sc_hd__and3_2_2 r0 *1 0,0
Xsky130_fd_sc_hd__and3_2_2 gate_cnt[15] gate_cnt[16] \_0392_ VSS VDD VDD
+ \_0412_ sky130_fd_sc_hd__and3_2
* cell instance sky130_fd_sc_hd__and3_2_3 r0 *1 0,0
Xsky130_fd_sc_hd__and3_2_3 gate_cnt[6] \_0389_ \_0391_ VSS VDD VDD \_0415_
+ sky130_fd_sc_hd__and3_2
* cell instance sky130_fd_sc_hd__and3_4_0 r0 *1 0,0
Xsky130_fd_sc_hd__and3_4_0 cnt_o[15] u_cnt/_037_ u_cnt/_084_ VSS VDD VDD
+ u_cnt/_038_ sky130_fd_sc_hd__and3_4
* cell instance sky130_fd_sc_hd__and3_4_1 r0 *1 0,0
Xsky130_fd_sc_hd__and3_4_1 cnt_o[13] u_cnt/_036_ u_cnt/_084_ VSS VDD VDD
+ u_cnt/_042_ sky130_fd_sc_hd__and3_4
* cell instance sky130_fd_sc_hd__and3_4_2 r0 *1 0,0
Xsky130_fd_sc_hd__and3_4_2 cnt_o[3] u_cnt/_068_ u_cnt/_084_ VSS VDD VDD
+ u_cnt/_086_ sky130_fd_sc_hd__and3_4
* cell instance sky130_fd_sc_hd__and3b_1_0 r0 *1 0,0
Xsky130_fd_sc_hd__and3b_1_0 \_0468_ \_0466_ \_0467_ VSS VDD VDD \_0479_
+ sky130_fd_sc_hd__and3b_1
* cell instance sky130_fd_sc_hd__and4_1_0 r0 *1 0,0
Xsky130_fd_sc_hd__and4_1_0 gate_cnt[22] gate_cnt[23] \_0388_ \_0393_ VSS VDD
+ VDD \_0394_ sky130_fd_sc_hd__and4_1
* cell instance sky130_fd_sc_hd__and4_4_0 r0 *1 0,0
Xsky130_fd_sc_hd__and4_4_0 cnt_o[17] cnt_o[18] cnt_o[19] u_cnt/_078_ VSS VDD
+ VDD u_cnt/_079_ sky130_fd_sc_hd__and4_4
* cell instance sky130_fd_sc_hd__and4_4_1 r0 *1 0,0
Xsky130_fd_sc_hd__and4_4_1 gate_cnt[15] gate_cnt[16] gate_cnt[17] \_0392_ VSS
+ VDD VDD \_0393_ sky130_fd_sc_hd__and4_4
* cell instance sky130_fd_sc_hd__and4_4_2 r0 *1 0,0
Xsky130_fd_sc_hd__and4_4_2 gate_cnt[2] gate_cnt[1] gate_cnt[0] gate_en VSS VDD
+ VDD \_0390_ sky130_fd_sc_hd__and4_4
* cell instance sky130_fd_sc_hd__and4_4_3 r0 *1 0,0
Xsky130_fd_sc_hd__and4_4_3 gate_cnt[4] gate_cnt[3] gate_cnt[5] \_0390_ VSS VDD
+ VDD \_0391_ sky130_fd_sc_hd__and4_4
* cell instance sky130_fd_sc_hd__and4_4_4 r0 *1 0,0
Xsky130_fd_sc_hd__and4_4_4 gate_cnt[6] \_0370_ \_0389_ \_0391_ VSS VDD VDD
+ \_0392_ sky130_fd_sc_hd__and4_4
* cell instance sky130_fd_sc_hd__and4b_1_0 r0 *1 0,0
Xsky130_fd_sc_hd__and4b_1_0 sel_q[2] sel_q[1] osc[3] sel_q[0] VSS VDD VDD
+ \_0336_ sky130_fd_sc_hd__and4b_1
* cell instance sky130_fd_sc_hd__and4b_1_1 r0 *1 0,0
Xsky130_fd_sc_hd__and4b_1_1 \_0737_ \_0766_ \_0298_ \_0317_ VSS VDD VDD \_0318_
+ sky130_fd_sc_hd__and4b_1
* cell instance sky130_fd_sc_hd__buf_2_0 r0 *1 0,0
Xsky130_fd_sc_hd__buf_2_0 addr[0] VSS VDD VDD \_0468_ sky130_fd_sc_hd__buf_2
* cell instance sky130_fd_sc_hd__buf_2_1 r0 *1 0,0
Xsky130_fd_sc_hd__buf_2_1 addr[1] VSS VDD VDD \_0466_ sky130_fd_sc_hd__buf_2
* cell instance sky130_fd_sc_hd__buf_4_0 r0 *1 0,0
Xsky130_fd_sc_hd__buf_4_0 clknet_2_2__leaf_clk_ref VSS VDD VDD
+ clknet_leaf_8_clk_ref sky130_fd_sc_hd__buf_4
* cell instance sky130_fd_sc_hd__buf_4_1 r0 *1 0,0
Xsky130_fd_sc_hd__buf_4_1 clknet_2_0__leaf_clk_ref VSS VDD VDD
+ clknet_leaf_38_clk_ref sky130_fd_sc_hd__buf_4
* cell instance sky130_fd_sc_hd__buf_4_2 r0 *1 0,0
Xsky130_fd_sc_hd__buf_4_2 clknet_2_0__leaf_clk_ref VSS VDD VDD
+ clknet_leaf_40_clk_ref sky130_fd_sc_hd__buf_4
* cell instance sky130_fd_sc_hd__buf_4_3 r0 *1 0,0
Xsky130_fd_sc_hd__buf_4_3 clknet_2_2__leaf_clk_ref VSS VDD VDD
+ clknet_leaf_5_clk_ref sky130_fd_sc_hd__buf_4
* cell instance sky130_fd_sc_hd__buf_4_4 r0 *1 0,0
Xsky130_fd_sc_hd__buf_4_4 clknet_2_0__leaf_clk_ref VSS VDD VDD
+ clknet_leaf_0_clk_ref sky130_fd_sc_hd__buf_4
* cell instance sky130_fd_sc_hd__buf_4_5 r0 *1 0,0
Xsky130_fd_sc_hd__buf_4_5 clknet_2_2__leaf_clk_ref VSS VDD VDD
+ clknet_leaf_9_clk_ref sky130_fd_sc_hd__buf_4
* cell instance sky130_fd_sc_hd__buf_4_6 r0 *1 0,0
Xsky130_fd_sc_hd__buf_4_6 clknet_2_2__leaf_clk_ref VSS VDD VDD
+ clknet_leaf_6_clk_ref sky130_fd_sc_hd__buf_4
* cell instance sky130_fd_sc_hd__buf_4_7 r0 *1 0,0
Xsky130_fd_sc_hd__buf_4_7 clknet_2_0__leaf_clk_ref VSS VDD VDD
+ clknet_leaf_37_clk_ref sky130_fd_sc_hd__buf_4
* cell instance sky130_fd_sc_hd__buf_4_8 r0 *1 0,0
Xsky130_fd_sc_hd__buf_4_8 clknet_2_0__leaf_clk_ref VSS VDD VDD
+ clknet_leaf_39_clk_ref sky130_fd_sc_hd__buf_4
* cell instance sky130_fd_sc_hd__buf_4_9 r0 *1 0,0
Xsky130_fd_sc_hd__buf_4_9 \_0472_ VSS VDD VDD net21 sky130_fd_sc_hd__buf_4
* cell instance sky130_fd_sc_hd__buf_4_10 r0 *1 0,0
Xsky130_fd_sc_hd__buf_4_10 \_0472_ VSS VDD VDD net22 sky130_fd_sc_hd__buf_4
* cell instance sky130_fd_sc_hd__buf_4_11 r0 *1 0,0
Xsky130_fd_sc_hd__buf_4_11 clknet_2_2__leaf_clk_ref VSS VDD VDD
+ clknet_leaf_7_clk_ref sky130_fd_sc_hd__buf_4
* cell instance sky130_fd_sc_hd__buf_4_12 r0 *1 0,0
Xsky130_fd_sc_hd__buf_4_12 clknet_2_2__leaf_clk_ref VSS VDD VDD
+ clknet_leaf_10_clk_ref sky130_fd_sc_hd__buf_4
* cell instance sky130_fd_sc_hd__buf_4_13 r0 *1 0,0
Xsky130_fd_sc_hd__buf_4_13 \_0359_ VSS VDD VDD net11 sky130_fd_sc_hd__buf_4
* cell instance sky130_fd_sc_hd__buf_4_14 r0 *1 0,0
Xsky130_fd_sc_hd__buf_4_14 clknet_2_0__leaf_clk_ref VSS VDD VDD
+ clknet_leaf_1_clk_ref sky130_fd_sc_hd__buf_4
* cell instance sky130_fd_sc_hd__buf_4_15 r0 *1 0,0
Xsky130_fd_sc_hd__buf_4_15 \_0470_ VSS VDD VDD net18 sky130_fd_sc_hd__buf_4
* cell instance sky130_fd_sc_hd__buf_4_16 r0 *1 0,0
Xsky130_fd_sc_hd__buf_4_16 clknet_2_0__leaf_clk_ref VSS VDD VDD
+ clknet_leaf_36_clk_ref sky130_fd_sc_hd__buf_4
* cell instance sky130_fd_sc_hd__buf_4_17 r0 *1 0,0
Xsky130_fd_sc_hd__buf_4_17 \_0500_ VSS VDD VDD net19 sky130_fd_sc_hd__buf_4
* cell instance sky130_fd_sc_hd__buf_4_18 r0 *1 0,0
Xsky130_fd_sc_hd__buf_4_18 \_0493_ VSS VDD VDD net20 sky130_fd_sc_hd__buf_4
* cell instance sky130_fd_sc_hd__buf_4_19 r0 *1 0,0
Xsky130_fd_sc_hd__buf_4_19 \_0315_ VSS VDD VDD net13 sky130_fd_sc_hd__buf_4
* cell instance sky130_fd_sc_hd__buf_4_20 r0 *1 0,0
Xsky130_fd_sc_hd__buf_4_20 clknet_0_clk_ref VSS VDD VDD
+ clknet_2_0__leaf_clk_ref sky130_fd_sc_hd__buf_4
* cell instance sky130_fd_sc_hd__buf_4_21 r0 *1 0,0
Xsky130_fd_sc_hd__buf_4_21 \_0450_ VSS VDD VDD net10 sky130_fd_sc_hd__buf_4
* cell instance sky130_fd_sc_hd__buf_4_22 r0 *1 0,0
Xsky130_fd_sc_hd__buf_4_22 clknet_2_2__leaf_clk_ref VSS VDD VDD
+ clknet_leaf_4_clk_ref sky130_fd_sc_hd__buf_4
* cell instance sky130_fd_sc_hd__buf_4_23 r0 *1 0,0
Xsky130_fd_sc_hd__buf_4_23 clknet_0_clk_ref VSS VDD VDD
+ clknet_2_2__leaf_clk_ref sky130_fd_sc_hd__buf_4
* cell instance sky130_fd_sc_hd__buf_4_24 r0 *1 0,0
Xsky130_fd_sc_hd__buf_4_24 clknet_2_2__leaf_clk_ref VSS VDD VDD
+ clknet_leaf_11_clk_ref sky130_fd_sc_hd__buf_4
* cell instance sky130_fd_sc_hd__buf_4_25 r0 *1 0,0
Xsky130_fd_sc_hd__buf_4_25 clknet_2_0__leaf_clk_ref VSS VDD VDD
+ clknet_leaf_2_clk_ref sky130_fd_sc_hd__buf_4
* cell instance sky130_fd_sc_hd__buf_4_26 r0 *1 0,0
Xsky130_fd_sc_hd__buf_4_26 clknet_2_0__leaf_clk_ref VSS VDD VDD
+ clknet_leaf_33_clk_ref sky130_fd_sc_hd__buf_4
* cell instance sky130_fd_sc_hd__buf_4_27 r0 *1 0,0
Xsky130_fd_sc_hd__buf_4_27 clknet_2_0__leaf_clk_ref VSS VDD VDD
+ clknet_leaf_35_clk_ref sky130_fd_sc_hd__buf_4
* cell instance sky130_fd_sc_hd__buf_4_28 r0 *1 0,0
Xsky130_fd_sc_hd__buf_4_28 clknet_2_2__leaf_clk_ref VSS VDD VDD
+ clknet_leaf_3_clk_ref sky130_fd_sc_hd__buf_4
* cell instance sky130_fd_sc_hd__buf_4_29 r0 *1 0,0
Xsky130_fd_sc_hd__buf_4_29 \_0353_ VSS VDD VDD net12 sky130_fd_sc_hd__buf_4
* cell instance sky130_fd_sc_hd__buf_4_30 r0 *1 0,0
Xsky130_fd_sc_hd__buf_4_30 clknet_2_2__leaf_clk_ref VSS VDD VDD
+ clknet_leaf_13_clk_ref sky130_fd_sc_hd__buf_4
* cell instance sky130_fd_sc_hd__buf_4_31 r0 *1 0,0
Xsky130_fd_sc_hd__buf_4_31 clknet_2_2__leaf_clk_ref VSS VDD VDD
+ clknet_leaf_12_clk_ref sky130_fd_sc_hd__buf_4
* cell instance sky130_fd_sc_hd__buf_4_32 r0 *1 0,0
Xsky130_fd_sc_hd__buf_4_32 clknet_2_2__leaf_clk_ref VSS VDD VDD
+ clknet_leaf_14_clk_ref sky130_fd_sc_hd__buf_4
* cell instance sky130_fd_sc_hd__buf_4_33 r0 *1 0,0
Xsky130_fd_sc_hd__buf_4_33 clknet_2_1__leaf_clk_ref VSS VDD VDD
+ clknet_leaf_34_clk_ref sky130_fd_sc_hd__buf_4
* cell instance sky130_fd_sc_hd__buf_4_34 r0 *1 0,0
Xsky130_fd_sc_hd__buf_4_34 \_0483_ VSS VDD VDD net16 sky130_fd_sc_hd__buf_4
* cell instance sky130_fd_sc_hd__buf_4_35 r0 *1 0,0
Xsky130_fd_sc_hd__buf_4_35 \_0485_ VSS VDD VDD net14 sky130_fd_sc_hd__buf_4
* cell instance sky130_fd_sc_hd__buf_4_36 r0 *1 0,0
Xsky130_fd_sc_hd__buf_4_36 \_0485_ VSS VDD VDD net15 sky130_fd_sc_hd__buf_4
* cell instance sky130_fd_sc_hd__buf_4_37 r0 *1 0,0
Xsky130_fd_sc_hd__buf_4_37 \_0476_ VSS VDD VDD net17 sky130_fd_sc_hd__buf_4
* cell instance sky130_fd_sc_hd__buf_4_38 r0 *1 0,0
Xsky130_fd_sc_hd__buf_4_38 clknet_2_1__leaf_clk_ref VSS VDD VDD
+ clknet_leaf_32_clk_ref sky130_fd_sc_hd__buf_4
* cell instance sky130_fd_sc_hd__buf_4_39 r0 *1 0,0
Xsky130_fd_sc_hd__buf_4_39 clk_ref VSS VDD VDD clknet_0_clk_ref
+ sky130_fd_sc_hd__buf_4
* cell instance sky130_fd_sc_hd__buf_4_40 r0 *1 0,0
Xsky130_fd_sc_hd__buf_4_40 clknet_2_3__leaf_clk_ref VSS VDD VDD
+ clknet_leaf_15_clk_ref sky130_fd_sc_hd__buf_4
* cell instance sky130_fd_sc_hd__buf_4_41 r0 *1 0,0
Xsky130_fd_sc_hd__buf_4_41 clknet_2_1__leaf_clk_ref VSS VDD VDD
+ clknet_leaf_30_clk_ref sky130_fd_sc_hd__buf_4
* cell instance sky130_fd_sc_hd__buf_4_42 r0 *1 0,0
Xsky130_fd_sc_hd__buf_4_42 clknet_2_3__leaf_clk_ref VSS VDD VDD
+ clknet_leaf_16_clk_ref sky130_fd_sc_hd__buf_4
* cell instance sky130_fd_sc_hd__buf_4_43 r0 *1 0,0
Xsky130_fd_sc_hd__buf_4_43 clknet_2_1__leaf_clk_ref VSS VDD VDD
+ clknet_leaf_31_clk_ref sky130_fd_sc_hd__buf_4
* cell instance sky130_fd_sc_hd__buf_4_44 r0 *1 0,0
Xsky130_fd_sc_hd__buf_4_44 clknet_0_clk_ref VSS VDD VDD
+ clknet_2_1__leaf_clk_ref sky130_fd_sc_hd__buf_4
* cell instance sky130_fd_sc_hd__buf_4_45 r0 *1 0,0
Xsky130_fd_sc_hd__buf_4_45 clknet_0_clk_ref VSS VDD VDD
+ clknet_2_3__leaf_clk_ref sky130_fd_sc_hd__buf_4
* cell instance sky130_fd_sc_hd__buf_4_46 r0 *1 0,0
Xsky130_fd_sc_hd__buf_4_46 clknet_2_3__leaf_clk_ref VSS VDD VDD
+ clknet_leaf_17_clk_ref sky130_fd_sc_hd__buf_4
* cell instance sky130_fd_sc_hd__buf_4_47 r0 *1 0,0
Xsky130_fd_sc_hd__buf_4_47 clknet_2_3__leaf_clk_ref VSS VDD VDD
+ clknet_leaf_24_clk_ref sky130_fd_sc_hd__buf_4
* cell instance sky130_fd_sc_hd__buf_4_48 r0 *1 0,0
Xsky130_fd_sc_hd__buf_4_48 clknet_2_1__leaf_clk_ref VSS VDD VDD
+ clknet_leaf_29_clk_ref sky130_fd_sc_hd__buf_4
* cell instance sky130_fd_sc_hd__buf_4_49 r0 *1 0,0
Xsky130_fd_sc_hd__buf_4_49 clknet_2_3__leaf_clk_ref VSS VDD VDD
+ clknet_leaf_23_clk_ref sky130_fd_sc_hd__buf_4
* cell instance sky130_fd_sc_hd__buf_4_50 r0 *1 0,0
Xsky130_fd_sc_hd__buf_4_50 clknet_2_3__leaf_clk_ref VSS VDD VDD
+ clknet_leaf_18_clk_ref sky130_fd_sc_hd__buf_4
* cell instance sky130_fd_sc_hd__buf_4_51 r0 *1 0,0
Xsky130_fd_sc_hd__buf_4_51 clknet_2_1__leaf_clk_ref VSS VDD VDD
+ clknet_leaf_28_clk_ref sky130_fd_sc_hd__buf_4
* cell instance sky130_fd_sc_hd__buf_4_52 r0 *1 0,0
Xsky130_fd_sc_hd__buf_4_52 clknet_2_3__leaf_clk_ref VSS VDD VDD
+ clknet_leaf_22_clk_ref sky130_fd_sc_hd__buf_4
* cell instance sky130_fd_sc_hd__buf_4_53 r0 *1 0,0
Xsky130_fd_sc_hd__buf_4_53 clknet_2_3__leaf_clk_ref VSS VDD VDD
+ clknet_leaf_20_clk_ref sky130_fd_sc_hd__buf_4
* cell instance sky130_fd_sc_hd__buf_4_54 r0 *1 0,0
Xsky130_fd_sc_hd__buf_4_54 clknet_2_1__leaf_clk_ref VSS VDD VDD
+ clknet_leaf_26_clk_ref sky130_fd_sc_hd__buf_4
* cell instance sky130_fd_sc_hd__buf_4_55 r0 *1 0,0
Xsky130_fd_sc_hd__buf_4_55 clknet_2_3__leaf_clk_ref VSS VDD VDD
+ clknet_leaf_19_clk_ref sky130_fd_sc_hd__buf_4
* cell instance sky130_fd_sc_hd__buf_4_56 r0 *1 0,0
Xsky130_fd_sc_hd__buf_4_56 clknet_2_1__leaf_clk_ref VSS VDD VDD
+ clknet_leaf_27_clk_ref sky130_fd_sc_hd__buf_4
* cell instance sky130_fd_sc_hd__buf_4_57 r0 *1 0,0
Xsky130_fd_sc_hd__buf_4_57 clknet_2_3__leaf_clk_ref VSS VDD VDD
+ clknet_leaf_21_clk_ref sky130_fd_sc_hd__buf_4
* cell instance sky130_fd_sc_hd__buf_4_58 r0 *1 0,0
Xsky130_fd_sc_hd__buf_4_58 clknet_2_1__leaf_clk_ref VSS VDD VDD
+ clknet_leaf_25_clk_ref sky130_fd_sc_hd__buf_4
* cell instance sky130_fd_sc_hd__bufinv_16_0 r0 *1 0,0
Xsky130_fd_sc_hd__bufinv_16_0 clknet_2_1__leaf_clk_ref VSS VDD VDD \$1254
+ sky130_fd_sc_hd__bufinv_16
* cell instance sky130_fd_sc_hd__bufinv_16_1 r0 *1 0,0
Xsky130_fd_sc_hd__bufinv_16_1 clknet_leaf_24_clk_ref VSS VDD VDD \$2571
+ sky130_fd_sc_hd__bufinv_16
* cell instance sky130_fd_sc_hd__clkbuf_1_0 r0 *1 0,0
Xsky130_fd_sc_hd__clkbuf_1_0 addr[2] VSS VDD VDD \_0467_
+ sky130_fd_sc_hd__clkbuf_1
* cell instance sky130_fd_sc_hd__clkinv_1_0 r0 *1 0,0
Xsky130_fd_sc_hd__clkinv_1_0 clknet_leaf_5_clk_ref VSS VDD VDD \$2913
+ sky130_fd_sc_hd__clkinv_1
* cell instance sky130_fd_sc_hd__clkinv_1_1 r0 *1 0,0
Xsky130_fd_sc_hd__clkinv_1_1 clknet_leaf_40_clk_ref VSS VDD VDD \$1580
+ sky130_fd_sc_hd__clkinv_1
* cell instance sky130_fd_sc_hd__clkinv_1_2 r0 *1 0,0
Xsky130_fd_sc_hd__clkinv_1_2 clknet_leaf_9_clk_ref VSS VDD VDD \$4595
+ sky130_fd_sc_hd__clkinv_1
* cell instance sky130_fd_sc_hd__clkinv_1_3 r0 *1 0,0
Xsky130_fd_sc_hd__clkinv_1_3 clknet_leaf_6_clk_ref VSS VDD VDD \$3594
+ sky130_fd_sc_hd__clkinv_1
* cell instance sky130_fd_sc_hd__clkinv_1_4 r0 *1 0,0
Xsky130_fd_sc_hd__clkinv_1_4 clknet_leaf_7_clk_ref VSS VDD VDD \$3740
+ sky130_fd_sc_hd__clkinv_1
* cell instance sky130_fd_sc_hd__clkinv_1_5 r0 *1 0,0
Xsky130_fd_sc_hd__clkinv_1_5 clknet_leaf_1_clk_ref VSS VDD VDD \$2104
+ sky130_fd_sc_hd__clkinv_1
* cell instance sky130_fd_sc_hd__clkinv_1_6 r0 *1 0,0
Xsky130_fd_sc_hd__clkinv_1_6 clknet_leaf_11_clk_ref VSS VDD VDD \$4440
+ sky130_fd_sc_hd__clkinv_1
* cell instance sky130_fd_sc_hd__clkinv_1_7 r0 *1 0,0
Xsky130_fd_sc_hd__clkinv_1_7 clknet_leaf_3_clk_ref VSS VDD VDD \$2708
+ sky130_fd_sc_hd__clkinv_1
* cell instance sky130_fd_sc_hd__clkinv_1_8 r0 *1 0,0
Xsky130_fd_sc_hd__clkinv_1_8 clknet_leaf_13_clk_ref VSS VDD VDD \$4116
+ sky130_fd_sc_hd__clkinv_1
* cell instance sky130_fd_sc_hd__clkinv_1_9 r0 *1 0,0
Xsky130_fd_sc_hd__clkinv_1_9 clknet_leaf_17_clk_ref VSS VDD VDD \$4255
+ sky130_fd_sc_hd__clkinv_1
* cell instance sky130_fd_sc_hd__clkinv_1_10 r0 *1 0,0
Xsky130_fd_sc_hd__clkinv_1_10 clknet_leaf_18_clk_ref VSS VDD VDD \$4629
+ sky130_fd_sc_hd__clkinv_1
* cell instance sky130_fd_sc_hd__clkinv_1_11 r0 *1 0,0
Xsky130_fd_sc_hd__clkinv_1_11 clknet_leaf_28_clk_ref VSS VDD VDD \$800
+ sky130_fd_sc_hd__clkinv_1
* cell instance sky130_fd_sc_hd__clkinv_1_12 r0 *1 0,0
Xsky130_fd_sc_hd__clkinv_1_12 clknet_leaf_20_clk_ref VSS VDD VDD \$3794
+ sky130_fd_sc_hd__clkinv_1
* cell instance sky130_fd_sc_hd__clkinvlp_2_0 r0 *1 0,0
Xsky130_fd_sc_hd__clkinvlp_2_0 clknet_2_0__leaf_clk_ref VSS VDD VDD \$1222
+ sky130_fd_sc_hd__clkinvlp_2
* cell instance sky130_fd_sc_hd__clkinvlp_2_1 r0 *1 0,0
Xsky130_fd_sc_hd__clkinvlp_2_1 clknet_2_3__leaf_clk_ref VSS VDD VDD \$3637
+ sky130_fd_sc_hd__clkinvlp_2
* cell instance sky130_fd_sc_hd__conb_1_0 r0 *1 0,0
Xsky130_fd_sc_hd__conb_1_0 \$2373 \_0772_ VSS VDD VDD sky130_fd_sc_hd__conb_1
* cell instance sky130_fd_sc_hd__dfrtp_1_0 r0 *1 0,0
Xsky130_fd_sc_hd__dfrtp_1_0 clknet_leaf_38_clk_ref \_0270_ cal_r[2][23] rst_n
+ VSS VDD VDD sky130_fd_sc_hd__dfrtp_1
* cell instance sky130_fd_sc_hd__dfrtp_1_1 r0 *1 0,0
Xsky130_fd_sc_hd__dfrtp_1_1 clknet_leaf_38_clk_ref \_0206_ cal_r[0][23] rst_n
+ VSS VDD VDD sky130_fd_sc_hd__dfrtp_1
* cell instance sky130_fd_sc_hd__dfrtp_1_2 r0 *1 0,0
Xsky130_fd_sc_hd__dfrtp_1_2 clknet_leaf_38_clk_ref \_0196_ cal_r[1][13] rst_n
+ VSS VDD VDD sky130_fd_sc_hd__dfrtp_1
* cell instance sky130_fd_sc_hd__dfrtp_1_3 r0 *1 0,0
Xsky130_fd_sc_hd__dfrtp_1_3 clknet_leaf_38_clk_ref \_0291_ cal_r[0][13] rst_n
+ VSS VDD VDD sky130_fd_sc_hd__dfrtp_1
* cell instance sky130_fd_sc_hd__dfrtp_1_4 r0 *1 0,0
Xsky130_fd_sc_hd__dfrtp_1_4 clknet_leaf_39_clk_ref \_0135_ cal_r[3][20] rst_n
+ VSS VDD VDD sky130_fd_sc_hd__dfrtp_1
* cell instance sky130_fd_sc_hd__dfrtp_1_5 r0 *1 0,0
Xsky130_fd_sc_hd__dfrtp_1_5 clknet_leaf_40_clk_ref \_0001_ cal_r[0][12] rst_n
+ VSS VDD VDD sky130_fd_sc_hd__dfrtp_1
* cell instance sky130_fd_sc_hd__dfrtp_1_6 r0 *1 0,0
Xsky130_fd_sc_hd__dfrtp_1_6 clknet_leaf_40_clk_ref \_0236_ cal_r[4][12] rst_n
+ VSS VDD VDD sky130_fd_sc_hd__dfrtp_1
* cell instance sky130_fd_sc_hd__dfrtp_1_7 r0 *1 0,0
Xsky130_fd_sc_hd__dfrtp_1_7 clknet_leaf_40_clk_ref \_0197_ cal_r[1][12] rst_n
+ VSS VDD VDD sky130_fd_sc_hd__dfrtp_1
* cell instance sky130_fd_sc_hd__dfrtp_1_8 r0 *1 0,0
Xsky130_fd_sc_hd__dfrtp_1_8 clknet_leaf_0_clk_ref \_0225_ cal_r[1][0] rst_n VSS
+ VDD VDD sky130_fd_sc_hd__dfrtp_1
* cell instance sky130_fd_sc_hd__dfrtp_1_9 r0 *1 0,0
Xsky130_fd_sc_hd__dfrtp_1_9 clknet_leaf_0_clk_ref \_0287_ cal_r[0][17] rst_n
+ VSS VDD VDD sky130_fd_sc_hd__dfrtp_1
* cell instance sky130_fd_sc_hd__dfrtp_1_10 r0 *1 0,0
Xsky130_fd_sc_hd__dfrtp_1_10 clknet_leaf_5_clk_ref \_0192_ cal_r[1][17] rst_n
+ VSS VDD VDD sky130_fd_sc_hd__dfrtp_1
* cell instance sky130_fd_sc_hd__dfrtp_1_11 r0 *1 0,0
Xsky130_fd_sc_hd__dfrtp_1_11 clknet_leaf_5_clk_ref \_0012_ cal_r[0][1] rst_n
+ VSS VDD VDD sky130_fd_sc_hd__dfrtp_1
* cell instance sky130_fd_sc_hd__dfrtp_1_12 r0 *1 0,0
Xsky130_fd_sc_hd__dfrtp_1_12 clknet_leaf_6_clk_ref \_0289_ cal_r[0][15] rst_n
+ VSS VDD VDD sky130_fd_sc_hd__dfrtp_1
* cell instance sky130_fd_sc_hd__dfrtp_1_13 r0 *1 0,0
Xsky130_fd_sc_hd__dfrtp_1_13 clknet_leaf_6_clk_ref \_0092_ cal_r[2][15] rst_n
+ VSS VDD VDD sky130_fd_sc_hd__dfrtp_1
* cell instance sky130_fd_sc_hd__dfrtp_1_14 r0 *1 0,0
Xsky130_fd_sc_hd__dfrtp_1_14 clknet_leaf_8_clk_ref \_0285_ cal_r[0][19] rst_n
+ VSS VDD VDD sky130_fd_sc_hd__dfrtp_1
* cell instance sky130_fd_sc_hd__dfrtp_1_15 r0 *1 0,0
Xsky130_fd_sc_hd__dfrtp_1_15 clknet_leaf_8_clk_ref \_0187_ cal_r[1][22] rst_n
+ VSS VDD VDD sky130_fd_sc_hd__dfrtp_1
* cell instance sky130_fd_sc_hd__dfrtp_1_16 r0 *1 0,0
Xsky130_fd_sc_hd__dfrtp_1_16 clknet_leaf_9_clk_ref \_0133_ cal_r[3][22] rst_n
+ VSS VDD VDD sky130_fd_sc_hd__dfrtp_1
* cell instance sky130_fd_sc_hd__dfrtp_1_17 r0 *1 0,0
Xsky130_fd_sc_hd__dfrtp_1_17 clknet_leaf_9_clk_ref \_0190_ cal_r[1][19] rst_n
+ VSS VDD VDD sky130_fd_sc_hd__dfrtp_1
* cell instance sky130_fd_sc_hd__dfrtp_1_18 r0 *1 0,0
Xsky130_fd_sc_hd__dfrtp_1_18 clknet_leaf_5_clk_ref \_0154_ cal_r[3][1] rst_n
+ VSS VDD VDD sky130_fd_sc_hd__dfrtp_1
* cell instance sky130_fd_sc_hd__dfrtp_1_19 r0 *1 0,0
Xsky130_fd_sc_hd__dfrtp_1_19 clknet_leaf_6_clk_ref \_0140_ cal_r[3][15] rst_n
+ VSS VDD VDD sky130_fd_sc_hd__dfrtp_1
* cell instance sky130_fd_sc_hd__dfrtp_1_20 r0 *1 0,0
Xsky130_fd_sc_hd__dfrtp_1_20 clknet_leaf_9_clk_ref \_0229_ cal_r[4][19] rst_n
+ VSS VDD VDD sky130_fd_sc_hd__dfrtp_1
* cell instance sky130_fd_sc_hd__dfrtp_1_21 r0 *1 0,0
Xsky130_fd_sc_hd__dfrtp_1_21 clknet_leaf_40_clk_ref \_0095_ cal_r[2][12] rst_n
+ VSS VDD VDD sky130_fd_sc_hd__dfrtp_1
* cell instance sky130_fd_sc_hd__dfrtp_1_22 r0 *1 0,0
Xsky130_fd_sc_hd__dfrtp_1_22 clknet_leaf_8_clk_ref \_0108_ cal_r[2][22] rst_n
+ VSS VDD VDD sky130_fd_sc_hd__dfrtp_1
* cell instance sky130_fd_sc_hd__dfrtp_1_23 r0 *1 0,0
Xsky130_fd_sc_hd__dfrtp_1_23 clknet_leaf_37_clk_ref \_0220_ cal_r[3][23] rst_n
+ VSS VDD VDD sky130_fd_sc_hd__dfrtp_1
* cell instance sky130_fd_sc_hd__dfrtp_1_24 r0 *1 0,0
Xsky130_fd_sc_hd__dfrtp_1_24 clknet_leaf_38_clk_ref \_0214_ cal_r[1][23] rst_n
+ VSS VDD VDD sky130_fd_sc_hd__dfrtp_1
* cell instance sky130_fd_sc_hd__dfrtp_1_25 r0 *1 0,0
Xsky130_fd_sc_hd__dfrtp_1_25 clknet_leaf_0_clk_ref \_0107_ cal_r[2][0] rst_n
+ VSS VDD VDD sky130_fd_sc_hd__dfrtp_1
* cell instance sky130_fd_sc_hd__dfrtp_1_26 r0 *1 0,0
Xsky130_fd_sc_hd__dfrtp_1_26 clknet_leaf_5_clk_ref \_0090_ cal_r[2][17] rst_n
+ VSS VDD VDD sky130_fd_sc_hd__dfrtp_1
* cell instance sky130_fd_sc_hd__dfrtp_1_27 r0 *1 0,0
Xsky130_fd_sc_hd__dfrtp_1_27 clknet_leaf_8_clk_ref \_0088_ cal_r[2][19] rst_n
+ VSS VDD VDD sky130_fd_sc_hd__dfrtp_1
* cell instance sky130_fd_sc_hd__dfrtp_1_28 r0 *1 0,0
Xsky130_fd_sc_hd__dfrtp_1_28 clknet_leaf_0_clk_ref \_0231_ cal_r[4][17] rst_n
+ VSS VDD VDD sky130_fd_sc_hd__dfrtp_1
* cell instance sky130_fd_sc_hd__dfrtp_1_29 r0 *1 0,0
Xsky130_fd_sc_hd__dfrtp_1_29 clknet_leaf_38_clk_ref \_0094_ cal_r[2][13] rst_n
+ VSS VDD VDD sky130_fd_sc_hd__dfrtp_1
* cell instance sky130_fd_sc_hd__dfrtp_1_30 r0 *1 0,0
Xsky130_fd_sc_hd__dfrtp_1_30 clknet_leaf_8_clk_ref \_0282_ cal_r[0][22] rst_n
+ VSS VDD VDD sky130_fd_sc_hd__dfrtp_1
* cell instance sky130_fd_sc_hd__dfrtp_1_31 r0 *1 0,0
Xsky130_fd_sc_hd__dfrtp_1_31 clknet_leaf_6_clk_ref \_0194_ cal_r[1][15] rst_n
+ VSS VDD VDD sky130_fd_sc_hd__dfrtp_1
* cell instance sky130_fd_sc_hd__dfrtp_1_32 r0 *1 0,0
Xsky130_fd_sc_hd__dfrtp_1_32 clknet_leaf_37_clk_ref \_0213_ cal_r[4][23] rst_n
+ VSS VDD VDD sky130_fd_sc_hd__dfrtp_1
* cell instance sky130_fd_sc_hd__dfrtp_1_33 r0 *1 0,0
Xsky130_fd_sc_hd__dfrtp_1_33 clknet_leaf_8_clk_ref \_0226_ cal_r[4][22] rst_n
+ VSS VDD VDD sky130_fd_sc_hd__dfrtp_1
* cell instance sky130_fd_sc_hd__dfrtp_1_34 r0 *1 0,0
Xsky130_fd_sc_hd__dfrtp_1_34 clknet_leaf_9_clk_ref \_0136_ cal_r[3][19] rst_n
+ VSS VDD VDD sky130_fd_sc_hd__dfrtp_1
* cell instance sky130_fd_sc_hd__dfrtp_1_35 r0 *1 0,0
Xsky130_fd_sc_hd__dfrtp_1_35 clknet_leaf_38_clk_ref \_0142_ cal_r[3][13] rst_n
+ VSS VDD VDD sky130_fd_sc_hd__dfrtp_1
* cell instance sky130_fd_sc_hd__dfrtp_1_36 r0 *1 0,0
Xsky130_fd_sc_hd__dfrtp_1_36 clknet_leaf_40_clk_ref \_0143_ cal_r[3][12] rst_n
+ VSS VDD VDD sky130_fd_sc_hd__dfrtp_1
* cell instance sky130_fd_sc_hd__dfrtp_1_37 r0 *1 0,0
Xsky130_fd_sc_hd__dfrtp_1_37 clknet_leaf_5_clk_ref \_0138_ cal_r[3][17] rst_n
+ VSS VDD VDD sky130_fd_sc_hd__dfrtp_1
* cell instance sky130_fd_sc_hd__dfrtp_1_38 r0 *1 0,0
Xsky130_fd_sc_hd__dfrtp_1_38 clknet_leaf_8_clk_ref \_0233_ cal_r[4][15] rst_n
+ VSS VDD VDD sky130_fd_sc_hd__dfrtp_1
* cell instance sky130_fd_sc_hd__dfrtp_1_39 r0 *1 0,0
Xsky130_fd_sc_hd__dfrtp_1_39 clknet_leaf_0_clk_ref \_0248_ cal_r[4][0] rst_n
+ VSS VDD VDD sky130_fd_sc_hd__dfrtp_1
* cell instance sky130_fd_sc_hd__dfrtp_1_40 r0 *1 0,0
Xsky130_fd_sc_hd__dfrtp_1_40 clknet_leaf_39_clk_ref \_0228_ cal_r[4][20] rst_n
+ VSS VDD VDD sky130_fd_sc_hd__dfrtp_1
* cell instance sky130_fd_sc_hd__dfrtp_1_41 r0 *1 0,0
Xsky130_fd_sc_hd__dfrtp_1_41 clknet_leaf_9_clk_ref \_0089_ cal_r[2][18] rst_n
+ VSS VDD VDD sky130_fd_sc_hd__dfrtp_1
* cell instance sky130_fd_sc_hd__dfrtp_1_42 r0 *1 0,0
Xsky130_fd_sc_hd__dfrtp_1_42 clknet_leaf_5_clk_ref \_0106_ cal_r[2][1] rst_n
+ VSS VDD VDD sky130_fd_sc_hd__dfrtp_1
* cell instance sky130_fd_sc_hd__dfrtp_1_43 r0 *1 0,0
Xsky130_fd_sc_hd__dfrtp_1_43 clknet_leaf_8_clk_ref \_0003_ cal_r[0][10] rst_n
+ VSS VDD VDD sky130_fd_sc_hd__dfrtp_1
* cell instance sky130_fd_sc_hd__dfrtp_1_44 r0 *1 0,0
Xsky130_fd_sc_hd__dfrtp_1_44 clknet_leaf_0_clk_ref \_0155_ cal_r[3][0] rst_n
+ VSS VDD VDD sky130_fd_sc_hd__dfrtp_1
* cell instance sky130_fd_sc_hd__dfrtp_1_45 r0 *1 0,0
Xsky130_fd_sc_hd__dfrtp_1_45 clknet_leaf_6_clk_ref \_0224_ cal_r[1][1] rst_n
+ VSS VDD VDD sky130_fd_sc_hd__dfrtp_1
* cell instance sky130_fd_sc_hd__dfrtp_1_46 r0 *1 0,0
Xsky130_fd_sc_hd__dfrtp_1_46 clknet_leaf_9_clk_ref \_0199_ cal_r[1][10] rst_n
+ VSS VDD VDD sky130_fd_sc_hd__dfrtp_1
* cell instance sky130_fd_sc_hd__dfrtp_1_47 r0 *1 0,0
Xsky130_fd_sc_hd__dfrtp_1_47 clknet_leaf_38_clk_ref \_0235_ cal_r[4][13] rst_n
+ VSS VDD VDD sky130_fd_sc_hd__dfrtp_1
* cell instance sky130_fd_sc_hd__dfrtp_1_48 r0 *1 0,0
Xsky130_fd_sc_hd__dfrtp_1_48 clknet_leaf_39_clk_ref \_0087_ cal_r[2][20] rst_n
+ VSS VDD VDD sky130_fd_sc_hd__dfrtp_1
* cell instance sky130_fd_sc_hd__dfrtp_1_49 r0 *1 0,0
Xsky130_fd_sc_hd__dfrtp_1_49 clknet_leaf_6_clk_ref \_0097_ cal_r[2][10] rst_n
+ VSS VDD VDD sky130_fd_sc_hd__dfrtp_1
* cell instance sky130_fd_sc_hd__dfrtp_1_50 r0 *1 0,0
Xsky130_fd_sc_hd__dfrtp_1_50 clknet_leaf_6_clk_ref \_0011_ cal_r[0][2] rst_n
+ VSS VDD VDD sky130_fd_sc_hd__dfrtp_1
* cell instance sky130_fd_sc_hd__dfrtp_1_51 r0 *1 0,0
Xsky130_fd_sc_hd__dfrtp_1_51 clknet_leaf_10_clk_ref \_0286_ cal_r[0][18] rst_n
+ VSS VDD VDD sky130_fd_sc_hd__dfrtp_1
* cell instance sky130_fd_sc_hd__dfrtp_1_52 r0 *1 0,0
Xsky130_fd_sc_hd__dfrtp_1_52 clknet_leaf_5_clk_ref \_0086_ ctrl_sel[0] rst_n
+ VSS VDD VDD sky130_fd_sc_hd__dfrtp_1
* cell instance sky130_fd_sc_hd__dfrtp_1_53 r0 *1 0,0
Xsky130_fd_sc_hd__dfrtp_1_53 clknet_leaf_37_clk_ref \_0093_ cal_r[2][14] rst_n
+ VSS VDD VDD sky130_fd_sc_hd__dfrtp_1
* cell instance sky130_fd_sc_hd__dfrtp_1_54 r0 *1 0,0
Xsky130_fd_sc_hd__dfrtp_1_54 clknet_leaf_37_clk_ref \_0290_ cal_r[0][14] rst_n
+ VSS VDD VDD sky130_fd_sc_hd__dfrtp_1
* cell instance sky130_fd_sc_hd__dfrtp_1_55 r0 *1 0,0
Xsky130_fd_sc_hd__dfrtp_1_55 clknet_leaf_9_clk_ref \_0191_ cal_r[1][18] rst_n
+ VSS VDD VDD sky130_fd_sc_hd__dfrtp_1
* cell instance sky130_fd_sc_hd__dfrtp_1_56 r0 *1 0,0
Xsky130_fd_sc_hd__dfrtp_1_56 clknet_leaf_37_clk_ref \_0141_ cal_r[3][14] rst_n
+ VSS VDD VDD sky130_fd_sc_hd__dfrtp_1
* cell instance sky130_fd_sc_hd__dfrtp_1_57 r0 *1 0,0
Xsky130_fd_sc_hd__dfrtp_1_57 clknet_leaf_39_clk_ref \_0284_ cal_r[0][20] rst_n
+ VSS VDD VDD sky130_fd_sc_hd__dfrtp_1
* cell instance sky130_fd_sc_hd__dfrtp_1_58 r0 *1 0,0
Xsky130_fd_sc_hd__dfrtp_1_58 clknet_leaf_10_clk_ref \_0137_ cal_r[3][18] rst_n
+ VSS VDD VDD sky130_fd_sc_hd__dfrtp_1
* cell instance sky130_fd_sc_hd__dfrtp_1_59 r0 *1 0,0
Xsky130_fd_sc_hd__dfrtp_1_59 clknet_leaf_0_clk_ref \_0013_ cal_r[0][0] rst_n
+ VSS VDD VDD sky130_fd_sc_hd__dfrtp_1
* cell instance sky130_fd_sc_hd__dfrtp_1_60 r0 *1 0,0
Xsky130_fd_sc_hd__dfrtp_1_60 clknet_leaf_7_clk_ref \_0223_ cal_r[1][2] rst_n
+ VSS VDD VDD sky130_fd_sc_hd__dfrtp_1
* cell instance sky130_fd_sc_hd__dfrtp_1_61 r0 *1 0,0
Xsky130_fd_sc_hd__dfrtp_1_61 clknet_leaf_8_clk_ref \_0238_ cal_r[4][10] rst_n
+ VSS VDD VDD sky130_fd_sc_hd__dfrtp_1
* cell instance sky130_fd_sc_hd__dfrtp_1_62 r0 *1 0,0
Xsky130_fd_sc_hd__dfrtp_1_62 clknet_leaf_10_clk_ref \_0230_ cal_r[4][18] rst_n
+ VSS VDD VDD sky130_fd_sc_hd__dfrtp_1
* cell instance sky130_fd_sc_hd__dfrtp_1_63 r0 *1 0,0
Xsky130_fd_sc_hd__dfrtp_1_63 clknet_leaf_40_clk_ref \_0283_ cal_r[0][21] rst_n
+ VSS VDD VDD sky130_fd_sc_hd__dfrtp_1
* cell instance sky130_fd_sc_hd__dfrtp_1_64 r0 *1 0,0
Xsky130_fd_sc_hd__dfrtp_1_64 clknet_leaf_39_clk_ref \_0189_ cal_r[1][20] rst_n
+ VSS VDD VDD sky130_fd_sc_hd__dfrtp_1
* cell instance sky130_fd_sc_hd__dfrtp_1_65 r0 *1 0,0
Xsky130_fd_sc_hd__dfrtp_1_65 clknet_leaf_39_clk_ref \_0188_ cal_r[1][21] rst_n
+ VSS VDD VDD sky130_fd_sc_hd__dfrtp_1
* cell instance sky130_fd_sc_hd__dfrtp_1_66 r0 *1 0,0
Xsky130_fd_sc_hd__dfrtp_1_66 clknet_leaf_7_clk_ref \_0145_ cal_r[3][10] rst_n
+ VSS VDD VDD sky130_fd_sc_hd__dfrtp_1
* cell instance sky130_fd_sc_hd__dfrtp_1_67 r0 *1 0,0
Xsky130_fd_sc_hd__dfrtp_1_67 clknet_leaf_36_clk_ref \_0195_ cal_r[1][14] rst_n
+ VSS VDD VDD sky130_fd_sc_hd__dfrtp_1
* cell instance sky130_fd_sc_hd__dfrtp_1_68 r0 *1 0,0
Xsky130_fd_sc_hd__dfrtp_1_68 clknet_leaf_1_clk_ref \_0210_ busy_r rst_n VSS VDD
+ VDD sky130_fd_sc_hd__dfrtp_1
* cell instance sky130_fd_sc_hd__dfrtp_1_69 r0 *1 0,0
Xsky130_fd_sc_hd__dfrtp_1_69 clknet_leaf_7_clk_ref \_0153_ cal_r[3][2] rst_n
+ VSS VDD VDD sky130_fd_sc_hd__dfrtp_1
* cell instance sky130_fd_sc_hd__dfrtp_1_70 r0 *1 0,0
Xsky130_fd_sc_hd__dfrtp_1_70 clknet_leaf_4_clk_ref \_0247_ cal_r[4][1] rst_n
+ VSS VDD VDD sky130_fd_sc_hd__dfrtp_1
* cell instance sky130_fd_sc_hd__dfrtp_1_71 r0 *1 0,0
Xsky130_fd_sc_hd__dfrtp_1_71 clknet_leaf_37_clk_ref \_0234_ cal_r[4][14] rst_n
+ VSS VDD VDD sky130_fd_sc_hd__dfrtp_1
* cell instance sky130_fd_sc_hd__dfrtp_1_72 r0 *1 0,0
Xsky130_fd_sc_hd__dfrtp_1_72 clknet_leaf_7_clk_ref \_0105_ cal_r[2][2] rst_n
+ VSS VDD VDD sky130_fd_sc_hd__dfrtp_1
* cell instance sky130_fd_sc_hd__dfrtp_1_73 r0 *1 0,0
Xsky130_fd_sc_hd__dfrtp_1_73 clknet_leaf_7_clk_ref \_0151_ cal_r[3][4] rst_n
+ VSS VDD VDD sky130_fd_sc_hd__dfrtp_1
* cell instance sky130_fd_sc_hd__dfrtp_1_74 r0 *1 0,0
Xsky130_fd_sc_hd__dfrtp_1_74 clknet_leaf_10_clk_ref \_0096_ cal_r[2][11] rst_n
+ VSS VDD VDD sky130_fd_sc_hd__dfrtp_1
* cell instance sky130_fd_sc_hd__dfrtp_1_75 r0 *1 0,0
Xsky130_fd_sc_hd__dfrtp_1_75 clknet_leaf_36_clk_ref \_0139_ cal_r[3][16] rst_n
+ VSS VDD VDD sky130_fd_sc_hd__dfrtp_1
* cell instance sky130_fd_sc_hd__dfrtp_1_76 r0 *1 0,0
Xsky130_fd_sc_hd__dfrtp_1_76 clknet_leaf_1_clk_ref tog_s1 tog_s2 rst_n VSS VDD
+ VDD sky130_fd_sc_hd__dfrtp_1
* cell instance sky130_fd_sc_hd__dfrtp_1_77 r0 *1 0,0
Xsky130_fd_sc_hd__dfrtp_1_77 clknet_leaf_10_clk_ref \_0103_ cal_r[2][4] rst_n
+ VSS VDD VDD sky130_fd_sc_hd__dfrtp_1
* cell instance sky130_fd_sc_hd__dfrtp_1_78 r0 *1 0,0
Xsky130_fd_sc_hd__dfrtp_1_78 clknet_leaf_36_clk_ref \_0091_ cal_r[2][16] rst_n
+ VSS VDD VDD sky130_fd_sc_hd__dfrtp_1
* cell instance sky130_fd_sc_hd__dfrtp_1_79 r0 *1 0,0
Xsky130_fd_sc_hd__dfrtp_1_79 clknet_leaf_37_clk_ref \_0239_ cal_r[4][9] rst_n
+ VSS VDD VDD sky130_fd_sc_hd__dfrtp_1
* cell instance sky130_fd_sc_hd__dfrtp_1_80 r0 *1 0,0
Xsky130_fd_sc_hd__dfrtp_1_80 clknet_leaf_4_clk_ref \_0085_ ctrl_sel[1] rst_n
+ VSS VDD VDD sky130_fd_sc_hd__dfrtp_1
* cell instance sky130_fd_sc_hd__dfrtp_1_81 r0 *1 0,0
Xsky130_fd_sc_hd__dfrtp_1_81 clknet_leaf_7_clk_ref \_0246_ cal_r[4][2] rst_n
+ VSS VDD VDD sky130_fd_sc_hd__dfrtp_1
* cell instance sky130_fd_sc_hd__dfrtp_1_82 r0 *1 0,0
Xsky130_fd_sc_hd__dfrtp_1_82 clknet_leaf_1_clk_ref \_0134_ cal_r[3][21] rst_n
+ VSS VDD VDD sky130_fd_sc_hd__dfrtp_1
* cell instance sky130_fd_sc_hd__dfrtp_1_83 r0 *1 0,0
Xsky130_fd_sc_hd__dfrtp_1_83 clknet_leaf_7_clk_ref \_0009_ cal_r[0][4] rst_n
+ VSS VDD VDD sky130_fd_sc_hd__dfrtp_1
* cell instance sky130_fd_sc_hd__dfrtp_1_84 r0 *1 0,0
Xsky130_fd_sc_hd__dfrtp_1_84 clknet_leaf_1_clk_ref tog_s2 tog_s3 rst_n VSS VDD
+ VDD sky130_fd_sc_hd__dfrtp_1
* cell instance sky130_fd_sc_hd__dfrtp_1_85 r0 *1 0,0
Xsky130_fd_sc_hd__dfrtp_1_85 clknet_leaf_10_clk_ref \_0002_ cal_r[0][11] rst_n
+ VSS VDD VDD sky130_fd_sc_hd__dfrtp_1
* cell instance sky130_fd_sc_hd__dfrtp_1_86 r0 *1 0,0
Xsky130_fd_sc_hd__dfrtp_1_86 clknet_leaf_10_clk_ref \_0144_ cal_r[3][11] rst_n
+ VSS VDD VDD sky130_fd_sc_hd__dfrtp_1
* cell instance sky130_fd_sc_hd__dfrtp_1_87 r0 *1 0,0
Xsky130_fd_sc_hd__dfrtp_1_87 clknet_leaf_39_clk_ref \_0193_ cal_r[1][16] rst_n
+ VSS VDD VDD sky130_fd_sc_hd__dfrtp_1
* cell instance sky130_fd_sc_hd__dfrtp_1_88 r0 *1 0,0
Xsky130_fd_sc_hd__dfrtp_1_88 clknet_leaf_36_clk_ref \_0202_ cal_r[1][9] rst_n
+ VSS VDD VDD sky130_fd_sc_hd__dfrtp_1
* cell instance sky130_fd_sc_hd__dfrtp_1_89 r0 *1 0,0
Xsky130_fd_sc_hd__dfrtp_1_89 clknet_leaf_10_clk_ref \_0198_ cal_r[1][11] rst_n
+ VSS VDD VDD sky130_fd_sc_hd__dfrtp_1
* cell instance sky130_fd_sc_hd__dfrtp_1_90 r0 *1 0,0
Xsky130_fd_sc_hd__dfrtp_1_90 clknet_leaf_1_clk_ref \_0212_ done_r rst_n VSS VDD
+ VDD sky130_fd_sc_hd__dfrtp_1
* cell instance sky130_fd_sc_hd__dfrtp_1_91 r0 *1 0,0
Xsky130_fd_sc_hd__dfrtp_1_91 clknet_leaf_4_clk_ref \_0200_ ctrl_sel[2] rst_n
+ VSS VDD VDD sky130_fd_sc_hd__dfrtp_1
* cell instance sky130_fd_sc_hd__dfrtp_1_92 r0 *1 0,0
Xsky130_fd_sc_hd__dfrtp_1_92 clknet_leaf_11_clk_ref \_0221_ cal_r[1][4] rst_n
+ VSS VDD VDD sky130_fd_sc_hd__dfrtp_1
* cell instance sky130_fd_sc_hd__dfrtp_1_93 r0 *1 0,0
Xsky130_fd_sc_hd__dfrtp_1_93 clknet_leaf_36_clk_ref \_0098_ cal_r[2][9] rst_n
+ VSS VDD VDD sky130_fd_sc_hd__dfrtp_1
* cell instance sky130_fd_sc_hd__dfrtp_1_94 r0 *1 0,0
Xsky130_fd_sc_hd__dfrtp_1_94 clknet_leaf_4_clk_ref \_0038_ sel_q[0] rst_n VSS
+ VDD VDD sky130_fd_sc_hd__dfrtp_1
* cell instance sky130_fd_sc_hd__dfrtp_1_95 r0 *1 0,0
Xsky130_fd_sc_hd__dfrtp_1_95 clknet_leaf_33_clk_ref \_0227_ cal_r[4][21] rst_n
+ VSS VDD VDD sky130_fd_sc_hd__dfrtp_1
* cell instance sky130_fd_sc_hd__dfrtp_1_96 r0 *1 0,0
Xsky130_fd_sc_hd__dfrtp_1_96 clknet_leaf_4_clk_ref \_0222_ cal_r[1][3] rst_n
+ VSS VDD VDD sky130_fd_sc_hd__dfrtp_1
* cell instance sky130_fd_sc_hd__dfrtp_1_97 r0 *1 0,0
Xsky130_fd_sc_hd__dfrtp_1_97 clknet_leaf_11_clk_ref \_0244_ cal_r[4][4] rst_n
+ VSS VDD VDD sky130_fd_sc_hd__dfrtp_1
* cell instance sky130_fd_sc_hd__dfrtp_1_98 r0 *1 0,0
Xsky130_fd_sc_hd__dfrtp_1_98 clknet_leaf_36_clk_ref \_0288_ cal_r[0][16] rst_n
+ VSS VDD VDD sky130_fd_sc_hd__dfrtp_1
* cell instance sky130_fd_sc_hd__dfrtp_1_99 r0 *1 0,0
Xsky130_fd_sc_hd__dfrtp_1_99 clknet_leaf_2_clk_ref \_0102_ cal_r[2][5] rst_n
+ VSS VDD VDD sky130_fd_sc_hd__dfrtp_1
* cell instance sky130_fd_sc_hd__dfrtp_1_100 r0 *1 0,0
Xsky130_fd_sc_hd__dfrtp_1_100 clknet_leaf_4_clk_ref \_0010_ cal_r[0][3] rst_n
+ VSS VDD VDD sky130_fd_sc_hd__dfrtp_1
* cell instance sky130_fd_sc_hd__dfrtp_1_101 r0 *1 0,0
Xsky130_fd_sc_hd__dfrtp_1_101 clknet_leaf_11_clk_ref \_0237_ cal_r[4][11] rst_n
+ VSS VDD VDD sky130_fd_sc_hd__dfrtp_1
* cell instance sky130_fd_sc_hd__dfrtp_1_102 r0 *1 0,0
Xsky130_fd_sc_hd__dfrtp_1_102 clknet_leaf_4_clk_ref \_0101_ cal_r[2][6] rst_n
+ VSS VDD VDD sky130_fd_sc_hd__dfrtp_1
* cell instance sky130_fd_sc_hd__dfrtp_1_103 r0 *1 0,0
Xsky130_fd_sc_hd__dfrtp_1_103 clknet_leaf_36_clk_ref \_0232_ cal_r[4][16] rst_n
+ VSS VDD VDD sky130_fd_sc_hd__dfrtp_1
* cell instance sky130_fd_sc_hd__dfrtp_1_104 r0 *1 0,0
Xsky130_fd_sc_hd__dfrtp_1_104 clknet_leaf_35_clk_ref \_0146_ cal_r[3][9] rst_n
+ VSS VDD VDD sky130_fd_sc_hd__dfrtp_1
* cell instance sky130_fd_sc_hd__dfrtp_1_105 r0 *1 0,0
Xsky130_fd_sc_hd__dfrtp_1_105 clknet_leaf_2_clk_ref \_0215_ ovf_r rst_n VSS VDD
+ VDD sky130_fd_sc_hd__dfrtp_1
* cell instance sky130_fd_sc_hd__dfrtp_1_106 r0 *1 0,0
Xsky130_fd_sc_hd__dfrtp_1_106 clknet_leaf_3_clk_ref \_0037_ sel_q[1] rst_n VSS
+ VDD VDD sky130_fd_sc_hd__dfrtp_1
* cell instance sky130_fd_sc_hd__dfrtp_1_107 r0 *1 0,0
Xsky130_fd_sc_hd__dfrtp_1_107 clknet_leaf_14_clk_ref \_0007_ cal_r[0][6] rst_n
+ VSS VDD VDD sky130_fd_sc_hd__dfrtp_1
* cell instance sky130_fd_sc_hd__dfrtp_1_108 r0 *1 0,0
Xsky130_fd_sc_hd__dfrtp_1_108 clknet_leaf_11_clk_ref \_0148_ cal_r[3][7] rst_n
+ VSS VDD VDD sky130_fd_sc_hd__dfrtp_1
* cell instance sky130_fd_sc_hd__dfrtp_1_109 r0 *1 0,0
Xsky130_fd_sc_hd__dfrtp_1_109 clknet_leaf_36_clk_ref \_0004_ cal_r[0][9] rst_n
+ VSS VDD VDD sky130_fd_sc_hd__dfrtp_1
* cell instance sky130_fd_sc_hd__dfrtp_1_110 r0 *1 0,0
Xsky130_fd_sc_hd__dfrtp_1_110 clknet_leaf_2_clk_ref \_0243_ cal_r[4][5] rst_n
+ VSS VDD VDD sky130_fd_sc_hd__dfrtp_1
* cell instance sky130_fd_sc_hd__dfrtp_1_111 r0 *1 0,0
Xsky130_fd_sc_hd__dfrtp_1_111 clknet_leaf_2_clk_ref \_0008_ cal_r[0][5] rst_n
+ VSS VDD VDD sky130_fd_sc_hd__dfrtp_1
* cell instance sky130_fd_sc_hd__dfrtp_1_112 r0 *1 0,0
Xsky130_fd_sc_hd__dfrtp_1_112 clknet_leaf_2_clk_ref \_0109_ cal_r[2][21] rst_n
+ VSS VDD VDD sky130_fd_sc_hd__dfrtp_1
* cell instance sky130_fd_sc_hd__dfrtp_1_113 r0 *1 0,0
Xsky130_fd_sc_hd__dfrtp_1_113 clknet_leaf_11_clk_ref \_0005_ cal_r[0][8] rst_n
+ VSS VDD VDD sky130_fd_sc_hd__dfrtp_1
* cell instance sky130_fd_sc_hd__dfrtp_1_114 r0 *1 0,0
Xsky130_fd_sc_hd__dfrtp_1_114 clknet_leaf_33_clk_ref \_0063_ count_r[1][21]
+ rst_n VSS VDD VDD sky130_fd_sc_hd__dfrtp_1
* cell instance sky130_fd_sc_hd__dfrtp_1_115 r0 *1 0,0
Xsky130_fd_sc_hd__dfrtp_1_115 clknet_leaf_12_clk_ref \_0099_ cal_r[2][8] rst_n
+ VSS VDD VDD sky130_fd_sc_hd__dfrtp_1
* cell instance sky130_fd_sc_hd__dfrtp_1_116 r0 *1 0,0
Xsky130_fd_sc_hd__dfrtp_1_116 clknet_leaf_3_clk_ref \_0275_ ctrl_k[2] rst_n VSS
+ VDD VDD sky130_fd_sc_hd__dfrtp_1
* cell instance sky130_fd_sc_hd__dfrtp_1_117 r0 *1 0,0
Xsky130_fd_sc_hd__dfrtp_1_117 clknet_leaf_11_clk_ref \_0006_ cal_r[0][7] rst_n
+ VSS VDD VDD sky130_fd_sc_hd__dfrtp_1
* cell instance sky130_fd_sc_hd__dfrtp_1_118 r0 *1 0,0
Xsky130_fd_sc_hd__dfrtp_1_118 clknet_leaf_11_clk_ref \_0100_ cal_r[2][7] rst_n
+ VSS VDD VDD sky130_fd_sc_hd__dfrtp_1
* cell instance sky130_fd_sc_hd__dfrtp_1_119 r0 *1 0,0
Xsky130_fd_sc_hd__dfrtp_1_119 clknet_leaf_13_clk_ref \_0216_ cal_r[1][7] rst_n
+ VSS VDD VDD sky130_fd_sc_hd__dfrtp_1
* cell instance sky130_fd_sc_hd__dfrtp_1_120 r0 *1 0,0
Xsky130_fd_sc_hd__dfrtp_1_120 clknet_leaf_33_clk_ref \_0064_ count_r[1][20]
+ rst_n VSS VDD VDD sky130_fd_sc_hd__dfrtp_1
* cell instance sky130_fd_sc_hd__dfrtp_1_121 r0 *1 0,0
Xsky130_fd_sc_hd__dfrtp_1_121 clknet_leaf_35_clk_ref \_0255_ count_r[0][16]
+ rst_n VSS VDD VDD sky130_fd_sc_hd__dfrtp_1
* cell instance sky130_fd_sc_hd__dfrtp_1_122 r0 *1 0,0
Xsky130_fd_sc_hd__dfrtp_1_122 clknet_leaf_35_clk_ref \_0045_ count_r[3][16]
+ rst_n VSS VDD VDD sky130_fd_sc_hd__dfrtp_1
* cell instance sky130_fd_sc_hd__dfrtp_1_123 r0 *1 0,0
Xsky130_fd_sc_hd__dfrtp_1_123 clknet_leaf_35_clk_ref \_0068_ count_r[1][16]
+ rst_n VSS VDD VDD sky130_fd_sc_hd__dfrtp_1
* cell instance sky130_fd_sc_hd__dfrtp_1_124 r0 *1 0,0
Xsky130_fd_sc_hd__dfrtp_1_124 clknet_leaf_33_clk_ref \_0250_ count_r[0][21]
+ rst_n VSS VDD VDD sky130_fd_sc_hd__dfrtp_1
* cell instance sky130_fd_sc_hd__dfrtp_1_125 r0 *1 0,0
Xsky130_fd_sc_hd__dfrtp_1_125 clknet_leaf_2_clk_ref \_0218_ cal_r[1][5] rst_n
+ VSS VDD VDD sky130_fd_sc_hd__dfrtp_1
* cell instance sky130_fd_sc_hd__dfrtp_1_126 r0 *1 0,0
Xsky130_fd_sc_hd__dfrtp_1_126 clknet_leaf_14_clk_ref \_0104_ cal_r[2][3] rst_n
+ VSS VDD VDD sky130_fd_sc_hd__dfrtp_1
* cell instance sky130_fd_sc_hd__dfrtp_1_127 r0 *1 0,0
Xsky130_fd_sc_hd__dfrtp_1_127 clknet_leaf_13_clk_ref \_0241_ cal_r[4][7] rst_n
+ VSS VDD VDD sky130_fd_sc_hd__dfrtp_1
* cell instance sky130_fd_sc_hd__dfrtp_1_128 r0 *1 0,0
Xsky130_fd_sc_hd__dfrtp_1_128 clknet_leaf_33_clk_ref \_0254_ count_r[0][17]
+ rst_n VSS VDD VDD sky130_fd_sc_hd__dfrtp_1
* cell instance sky130_fd_sc_hd__dfrtp_1_129 r0 *1 0,0
Xsky130_fd_sc_hd__dfrtp_1_129 clknet_leaf_3_clk_ref \_0204_ sel_q[2] rst_n VSS
+ VDD VDD sky130_fd_sc_hd__dfrtp_1
* cell instance sky130_fd_sc_hd__dfrtp_1_130 r0 *1 0,0
Xsky130_fd_sc_hd__dfrtp_1_130 clknet_leaf_12_clk_ref \_0211_ cal_r[1][8] rst_n
+ VSS VDD VDD sky130_fd_sc_hd__dfrtp_1
* cell instance sky130_fd_sc_hd__dfrtp_1_131 r0 *1 0,0
Xsky130_fd_sc_hd__dfrtp_1_131 clknet_leaf_33_clk_ref \_0251_ count_r[0][20]
+ rst_n VSS VDD VDD sky130_fd_sc_hd__dfrtp_1
* cell instance sky130_fd_sc_hd__dfrtp_1_132 r0 *1 0,0
Xsky130_fd_sc_hd__dfrtp_1_132 clknet_leaf_2_clk_ref \_0150_ cal_r[3][5] rst_n
+ VSS VDD VDD sky130_fd_sc_hd__dfrtp_1
* cell instance sky130_fd_sc_hd__dfrtp_1_133 r0 *1 0,0
Xsky130_fd_sc_hd__dfrtp_1_133 clknet_leaf_13_clk_ref \_0217_ cal_r[1][6] rst_n
+ VSS VDD VDD sky130_fd_sc_hd__dfrtp_1
* cell instance sky130_fd_sc_hd__dfrtp_1_134 r0 *1 0,0
Xsky130_fd_sc_hd__dfrtp_1_134 clknet_leaf_12_clk_ref \_0240_ cal_r[4][8] rst_n
+ VSS VDD VDD sky130_fd_sc_hd__dfrtp_1
* cell instance sky130_fd_sc_hd__dfrtp_1_135 r0 *1 0,0
Xsky130_fd_sc_hd__dfrtp_1_135 clknet_leaf_35_clk_ref \_0020_ count_r[2][16]
+ rst_n VSS VDD VDD sky130_fd_sc_hd__dfrtp_1
* cell instance sky130_fd_sc_hd__dfrtp_1_136 r0 *1 0,0
Xsky130_fd_sc_hd__dfrtp_1_136 clknet_leaf_2_clk_ref tog_o tog_s1 rst_n VSS VDD
+ VDD sky130_fd_sc_hd__dfrtp_1
* cell instance sky130_fd_sc_hd__dfrtp_1_137 r0 *1 0,0
Xsky130_fd_sc_hd__dfrtp_1_137 clknet_leaf_33_clk_ref \_0044_ count_r[3][17]
+ rst_n VSS VDD VDD sky130_fd_sc_hd__dfrtp_1
* cell instance sky130_fd_sc_hd__dfrtp_1_138 r0 *1 0,0
Xsky130_fd_sc_hd__dfrtp_1_138 clknet_leaf_33_clk_ref \_0067_ count_r[1][17]
+ rst_n VSS VDD VDD sky130_fd_sc_hd__dfrtp_1
* cell instance sky130_fd_sc_hd__dfrtp_1_139 r0 *1 0,0
Xsky130_fd_sc_hd__dfrtp_1_139 clknet_leaf_35_clk_ref \_0116_ count_r[4][16]
+ rst_n VSS VDD VDD sky130_fd_sc_hd__dfrtp_1
* cell instance sky130_fd_sc_hd__dfrtp_1_140 r0 *1 0,0
Xsky130_fd_sc_hd__dfrtp_1_140 clknet_leaf_34_clk_ref \_0043_ count_r[3][18]
+ rst_n VSS VDD VDD sky130_fd_sc_hd__dfrtp_1
* cell instance sky130_fd_sc_hd__dfrtp_1_141 r0 *1 0,0
Xsky130_fd_sc_hd__dfrtp_1_141 clknet_leaf_34_clk_ref \_0019_ count_r[2][17]
+ rst_n VSS VDD VDD sky130_fd_sc_hd__dfrtp_1
* cell instance sky130_fd_sc_hd__dfrtp_1_142 r0 *1 0,0
Xsky130_fd_sc_hd__dfrtp_1_142 clknet_leaf_14_clk_ref \_0149_ cal_r[3][6] rst_n
+ VSS VDD VDD sky130_fd_sc_hd__dfrtp_1
* cell instance sky130_fd_sc_hd__dfrtp_1_143 r0 *1 0,0
Xsky130_fd_sc_hd__dfrtp_1_143 clknet_leaf_14_clk_ref \_0152_ cal_r[3][3] rst_n
+ VSS VDD VDD sky130_fd_sc_hd__dfrtp_1
* cell instance sky130_fd_sc_hd__dfrtp_1_144 r0 *1 0,0
Xsky130_fd_sc_hd__dfrtp_1_144 clknet_leaf_13_clk_ref \_0281_ k_q[0] rst_n VSS
+ VDD VDD sky130_fd_sc_hd__dfrtp_1
* cell instance sky130_fd_sc_hd__dfrtp_1_145 r0 *1 0,0
Xsky130_fd_sc_hd__dfrtp_1_145 clknet_leaf_12_clk_ref \_0147_ cal_r[3][8] rst_n
+ VSS VDD VDD sky130_fd_sc_hd__dfrtp_1
* cell instance sky130_fd_sc_hd__dfrtp_1_146 r0 *1 0,0
Xsky130_fd_sc_hd__dfrtp_1_146 clknet_leaf_15_clk_ref \_0083_ count_r[1][1]
+ rst_n VSS VDD VDD sky130_fd_sc_hd__dfrtp_1
* cell instance sky130_fd_sc_hd__dfrtp_1_147 r0 *1 0,0
Xsky130_fd_sc_hd__dfrtp_1_147 clknet_leaf_13_clk_ref \_0161_ gate_cnt[25] rst_n
+ VSS VDD VDD sky130_fd_sc_hd__dfrtp_1
* cell instance sky130_fd_sc_hd__dfrtp_1_148 r0 *1 0,0
Xsky130_fd_sc_hd__dfrtp_1_148 clknet_leaf_32_clk_ref \_0084_ count_r[1][0]
+ rst_n VSS VDD VDD sky130_fd_sc_hd__dfrtp_1
* cell instance sky130_fd_sc_hd__dfrtp_1_149 r0 *1 0,0
Xsky130_fd_sc_hd__dfrtp_1_149 clknet_leaf_14_clk_ref \_0208_ ctrl_k[4] rst_n
+ VSS VDD VDD sky130_fd_sc_hd__dfrtp_1
* cell instance sky130_fd_sc_hd__dfrtp_1_150 r0 *1 0,0
Xsky130_fd_sc_hd__dfrtp_1_150 clknet_leaf_3_clk_ref \_0277_ ctrl_k[0] rst_n VSS
+ VDD VDD sky130_fd_sc_hd__dfrtp_1
* cell instance sky130_fd_sc_hd__dfrtp_1_151 r0 *1 0,0
Xsky130_fd_sc_hd__dfrtp_1_151 clknet_leaf_3_clk_ref \_0060_ count_r[3][1] rst_n
+ VSS VDD VDD sky130_fd_sc_hd__dfrtp_1
* cell instance sky130_fd_sc_hd__dfrtp_1_152 r0 *1 0,0
Xsky130_fd_sc_hd__dfrtp_1_152 clknet_leaf_34_clk_ref \_0112_ count_r[4][20]
+ rst_n VSS VDD VDD sky130_fd_sc_hd__dfrtp_1
* cell instance sky130_fd_sc_hd__dfrtp_1_153 r0 *1 0,0
Xsky130_fd_sc_hd__dfrtp_1_153 clknet_leaf_34_clk_ref \_0041_ count_r[3][20]
+ rst_n VSS VDD VDD sky130_fd_sc_hd__dfrtp_1
* cell instance sky130_fd_sc_hd__dfrtp_1_154 r0 *1 0,0
Xsky130_fd_sc_hd__dfrtp_1_154 clknet_leaf_14_clk_ref \_0242_ cal_r[4][6] rst_n
+ VSS VDD VDD sky130_fd_sc_hd__dfrtp_1
* cell instance sky130_fd_sc_hd__dfrtp_1_155 r0 *1 0,0
Xsky130_fd_sc_hd__dfrtp_1_155 clknet_leaf_35_clk_ref \_0253_ count_r[0][18]
+ rst_n VSS VDD VDD sky130_fd_sc_hd__dfrtp_1
* cell instance sky130_fd_sc_hd__dfrtp_1_156 r0 *1 0,0
Xsky130_fd_sc_hd__dfrtp_1_156 clknet_leaf_34_clk_ref \_0015_ count_r[2][21]
+ rst_n VSS VDD VDD sky130_fd_sc_hd__dfrtp_1
* cell instance sky130_fd_sc_hd__dfrtp_1_157 r0 *1 0,0
Xsky130_fd_sc_hd__dfrtp_1_157 clknet_leaf_32_clk_ref \_0040_ count_r[3][21]
+ rst_n VSS VDD VDD sky130_fd_sc_hd__dfrtp_1
* cell instance sky130_fd_sc_hd__dfrtp_1_158 r0 *1 0,0
Xsky130_fd_sc_hd__dfrtp_1_158 clknet_leaf_13_clk_ref \_0159_ gate_cnt[27] rst_n
+ VSS VDD VDD sky130_fd_sc_hd__dfrtp_1
* cell instance sky130_fd_sc_hd__dfrtp_1_159 r0 *1 0,0
Xsky130_fd_sc_hd__dfrtp_1_159 clknet_leaf_12_clk_ref \_0163_ gate_cnt[23] rst_n
+ VSS VDD VDD sky130_fd_sc_hd__dfrtp_1
* cell instance sky130_fd_sc_hd__dfrtp_1_160 r0 *1 0,0
Xsky130_fd_sc_hd__dfrtp_1_160 clknet_leaf_14_clk_ref \_0245_ cal_r[4][3] rst_n
+ VSS VDD VDD sky130_fd_sc_hd__dfrtp_1
* cell instance sky130_fd_sc_hd__dfrtp_1_161 r0 *1 0,0
Xsky130_fd_sc_hd__dfrtp_1_161 clknet_leaf_3_clk_ref \_0132_ count_r[4][0] rst_n
+ VSS VDD VDD sky130_fd_sc_hd__dfrtp_1
* cell instance sky130_fd_sc_hd__dfrtp_1_162 r0 *1 0,0
Xsky130_fd_sc_hd__dfrtp_1_162 clknet_leaf_12_clk_ref \_0164_ gate_cnt[22] rst_n
+ VSS VDD VDD sky130_fd_sc_hd__dfrtp_1
* cell instance sky130_fd_sc_hd__dfrtp_1_163 r0 *1 0,0
Xsky130_fd_sc_hd__dfrtp_1_163 clknet_leaf_3_clk_ref \_0036_ count_r[2][0] rst_n
+ VSS VDD VDD sky130_fd_sc_hd__dfrtp_1
* cell instance sky130_fd_sc_hd__dfrtp_1_164 r0 *1 0,0
Xsky130_fd_sc_hd__dfrtp_1_164 clknet_leaf_12_clk_ref \_0162_ gate_cnt[24] rst_n
+ VSS VDD VDD sky130_fd_sc_hd__dfrtp_1
* cell instance sky130_fd_sc_hd__dfrtp_1_165 r0 *1 0,0
Xsky130_fd_sc_hd__dfrtp_1_165 clknet_leaf_32_clk_ref \_0115_ count_r[4][17]
+ rst_n VSS VDD VDD sky130_fd_sc_hd__dfrtp_1
* cell instance sky130_fd_sc_hd__dfrtp_1_166 r0 *1 0,0
Xsky130_fd_sc_hd__dfrtp_1_166 clknet_leaf_34_clk_ref \_0066_ count_r[1][18]
+ rst_n VSS VDD VDD sky130_fd_sc_hd__dfrtp_1
* cell instance sky130_fd_sc_hd__dfrtp_1_167 r0 *1 0,0
Xsky130_fd_sc_hd__dfrtp_1_167 clknet_leaf_14_clk_ref \_0131_ count_r[4][1]
+ rst_n VSS VDD VDD sky130_fd_sc_hd__dfrtp_1
* cell instance sky130_fd_sc_hd__dfrtp_1_168 r0 *1 0,0
Xsky130_fd_sc_hd__dfrtp_1_168 clknet_leaf_13_clk_ref \_0160_ gate_cnt[26] rst_n
+ VSS VDD VDD sky130_fd_sc_hd__dfrtp_1
* cell instance sky130_fd_sc_hd__dfrtp_1_169 r0 *1 0,0
Xsky130_fd_sc_hd__dfrtp_1_169 clknet_leaf_34_clk_ref \_0111_ count_r[4][21]
+ rst_n VSS VDD VDD sky130_fd_sc_hd__dfrtp_1
* cell instance sky130_fd_sc_hd__dfrtp_1_170 r0 *1 0,0
Xsky130_fd_sc_hd__dfrtp_1_170 clknet_leaf_35_clk_ref \_0114_ count_r[4][18]
+ rst_n VSS VDD VDD sky130_fd_sc_hd__dfrtp_1
* cell instance sky130_fd_sc_hd__dfrtp_1_171 r0 *1 0,0
Xsky130_fd_sc_hd__dfrtp_1_171 clknet_leaf_32_clk_ref \_0259_ count_r[0][12]
+ rst_n VSS VDD VDD sky130_fd_sc_hd__dfrtp_1
* cell instance sky130_fd_sc_hd__dfrtp_1_172 r0 *1 0,0
Xsky130_fd_sc_hd__dfrtp_1_172 clknet_leaf_15_clk_ref \_0035_ count_r[2][1]
+ rst_n VSS VDD VDD sky130_fd_sc_hd__dfrtp_1
* cell instance sky130_fd_sc_hd__dfrtp_1_173 r0 *1 0,0
Xsky130_fd_sc_hd__dfrtp_1_173 clknet_leaf_32_clk_ref \_0024_ count_r[2][12]
+ rst_n VSS VDD VDD sky130_fd_sc_hd__dfrtp_1
* cell instance sky130_fd_sc_hd__dfrtp_1_174 r0 *1 0,0
Xsky130_fd_sc_hd__dfrtp_1_174 clknet_leaf_15_clk_ref \_0122_ count_r[4][10]
+ rst_n VSS VDD VDD sky130_fd_sc_hd__dfrtp_1
* cell instance sky130_fd_sc_hd__dfrtp_1_175 r0 *1 0,0
Xsky130_fd_sc_hd__dfrtp_1_175 clknet_leaf_30_clk_ref \_0018_ count_r[2][18]
+ rst_n VSS VDD VDD sky130_fd_sc_hd__dfrtp_1
* cell instance sky130_fd_sc_hd__dfrtp_1_176 r0 *1 0,0
Xsky130_fd_sc_hd__dfrtp_1_176 clknet_leaf_30_clk_ref \_0016_ count_r[2][20]
+ rst_n VSS VDD VDD sky130_fd_sc_hd__dfrtp_1
* cell instance sky130_fd_sc_hd__dfrtp_1_177 r0 *1 0,0
Xsky130_fd_sc_hd__dfrtp_1_177 clknet_leaf_15_clk_ref \_0051_ count_r[3][10]
+ rst_n VSS VDD VDD sky130_fd_sc_hd__dfrtp_1
* cell instance sky130_fd_sc_hd__dfrtp_1_178 r0 *1 0,0
Xsky130_fd_sc_hd__dfrtp_1_178 clknet_leaf_16_clk_ref \_0272_ count_r[0][1]
+ rst_n VSS VDD VDD sky130_fd_sc_hd__dfrtp_1
* cell instance sky130_fd_sc_hd__dfrtp_1_179 r0 *1 0,0
Xsky130_fd_sc_hd__dfrtp_1_179 clknet_leaf_16_clk_ref \_0279_ k_q[2] rst_n VSS
+ VDD VDD sky130_fd_sc_hd__dfrtp_1
* cell instance sky130_fd_sc_hd__dfrtp_1_180 r0 *1 0,0
Xsky130_fd_sc_hd__dfrtp_1_180 clknet_leaf_32_clk_ref \_0061_ count_r[3][0]
+ rst_n VSS VDD VDD sky130_fd_sc_hd__dfrtp_1
* cell instance sky130_fd_sc_hd__dfrtp_1_181 r0 *1 0,0
Xsky130_fd_sc_hd__dfrtp_1_181 clknet_leaf_17_clk_ref \_0165_ gate_cnt[21] rst_n
+ VSS VDD VDD sky130_fd_sc_hd__dfrtp_1
* cell instance sky130_fd_sc_hd__dfrtp_1_182 r0 *1 0,0
Xsky130_fd_sc_hd__dfrtp_1_182 clknet_leaf_31_clk_ref \_0014_ count_r[2][22]
+ rst_n VSS VDD VDD sky130_fd_sc_hd__dfrtp_1
* cell instance sky130_fd_sc_hd__dfrtp_1_183 r0 *1 0,0
Xsky130_fd_sc_hd__dfrtp_1_183 clknet_leaf_30_clk_ref \_0039_ count_r[3][22]
+ rst_n VSS VDD VDD sky130_fd_sc_hd__dfrtp_1
* cell instance sky130_fd_sc_hd__dfrtp_1_184 r0 *1 0,0
Xsky130_fd_sc_hd__dfrtp_1_184 clknet_leaf_16_clk_ref \_0207_ k_q[4] rst_n VSS
+ VDD VDD sky130_fd_sc_hd__dfrtp_1
* cell instance sky130_fd_sc_hd__dfrtp_1_185 r0 *1 0,0
Xsky130_fd_sc_hd__dfrtp_1_185 clknet_leaf_17_clk_ref \_0166_ gate_cnt[20] rst_n
+ VSS VDD VDD sky130_fd_sc_hd__dfrtp_1
* cell instance sky130_fd_sc_hd__dfrtp_1_186 r0 *1 0,0
Xsky130_fd_sc_hd__dfrtp_1_186 clknet_leaf_30_clk_ref \_0257_ count_r[0][14]
+ rst_n VSS VDD VDD sky130_fd_sc_hd__dfrtp_1
* cell instance sky130_fd_sc_hd__dfrtp_1_187 r0 *1 0,0
Xsky130_fd_sc_hd__dfrtp_1_187 clknet_leaf_30_clk_ref \_0118_ count_r[4][14]
+ rst_n VSS VDD VDD sky130_fd_sc_hd__dfrtp_1
* cell instance sky130_fd_sc_hd__dfrtp_1_188 r0 *1 0,0
Xsky130_fd_sc_hd__dfrtp_1_188 clknet_leaf_15_clk_ref \_0074_ count_r[1][10]
+ rst_n VSS VDD VDD sky130_fd_sc_hd__dfrtp_1
* cell instance sky130_fd_sc_hd__dfrtp_1_189 r0 *1 0,0
Xsky130_fd_sc_hd__dfrtp_1_189 clknet_leaf_30_clk_ref \_0022_ count_r[2][14]
+ rst_n VSS VDD VDD sky130_fd_sc_hd__dfrtp_1
* cell instance sky130_fd_sc_hd__dfrtp_1_190 r0 *1 0,0
Xsky130_fd_sc_hd__dfrtp_1_190 clknet_leaf_16_clk_ref \_0130_ count_r[4][2]
+ rst_n VSS VDD VDD sky130_fd_sc_hd__dfrtp_1
* cell instance sky130_fd_sc_hd__dfrtp_1_191 r0 *1 0,0
Xsky130_fd_sc_hd__dfrtp_1_191 clknet_leaf_31_clk_ref \_0110_ count_r[4][22]
+ rst_n VSS VDD VDD sky130_fd_sc_hd__dfrtp_1
* cell instance sky130_fd_sc_hd__dfrtp_1_192 r0 *1 0,0
Xsky130_fd_sc_hd__dfrtp_1_192 clknet_leaf_31_clk_ref \_0249_ count_r[0][22]
+ rst_n VSS VDD VDD sky130_fd_sc_hd__dfrtp_1
* cell instance sky130_fd_sc_hd__dfrtp_1_193 r0 *1 0,0
Xsky130_fd_sc_hd__dfrtp_1_193 clknet_leaf_31_clk_ref \_0072_ count_r[1][12]
+ rst_n VSS VDD VDD sky130_fd_sc_hd__dfrtp_1
* cell instance sky130_fd_sc_hd__dfrtp_1_194 r0 *1 0,0
Xsky130_fd_sc_hd__dfrtp_1_194 clknet_leaf_32_clk_ref \_0273_ count_r[0][0]
+ rst_n VSS VDD VDD sky130_fd_sc_hd__dfrtp_1
* cell instance sky130_fd_sc_hd__dfrtp_1_195 r0 *1 0,0
Xsky130_fd_sc_hd__dfrtp_1_195 clknet_leaf_30_clk_ref \_0047_ count_r[3][14]
+ rst_n VSS VDD VDD sky130_fd_sc_hd__dfrtp_1
* cell instance sky130_fd_sc_hd__dfrtp_1_196 r0 *1 0,0
Xsky130_fd_sc_hd__dfrtp_1_196 clknet_leaf_31_clk_ref \_0049_ count_r[3][12]
+ rst_n VSS VDD VDD sky130_fd_sc_hd__dfrtp_1
* cell instance sky130_fd_sc_hd__dfrtp_1_197 r0 *1 0,0
Xsky130_fd_sc_hd__dfrtp_1_197 clknet_leaf_24_clk_ref \_0026_ count_r[2][10]
+ rst_n VSS VDD VDD sky130_fd_sc_hd__dfrtp_1
* cell instance sky130_fd_sc_hd__dfrtp_1_198 r0 *1 0,0
Xsky130_fd_sc_hd__dfrtp_1_198 clknet_leaf_15_clk_ref \_0082_ count_r[1][2]
+ rst_n VSS VDD VDD sky130_fd_sc_hd__dfrtp_1
* cell instance sky130_fd_sc_hd__dfrtp_1_199 r0 *1 0,0
Xsky130_fd_sc_hd__dfrtp_1_199 clknet_leaf_16_clk_ref \_0000_ gate_en rst_n VSS
+ VDD VDD sky130_fd_sc_hd__dfrtp_1
* cell instance sky130_fd_sc_hd__dfrtp_1_200 r0 *1 0,0
Xsky130_fd_sc_hd__dfrtp_1_200 clknet_leaf_30_clk_ref \_0070_ count_r[1][14]
+ rst_n VSS VDD VDD sky130_fd_sc_hd__dfrtp_1
* cell instance sky130_fd_sc_hd__dfrtp_1_201 r0 *1 0,0
Xsky130_fd_sc_hd__dfrtp_1_201 clknet_leaf_29_clk_ref \_0046_ count_r[3][15]
+ rst_n VSS VDD VDD sky130_fd_sc_hd__dfrtp_1
* cell instance sky130_fd_sc_hd__dfrtp_1_202 r0 *1 0,0
Xsky130_fd_sc_hd__dfrtp_1_202 clknet_leaf_31_clk_ref \_0062_ count_r[1][22]
+ rst_n VSS VDD VDD sky130_fd_sc_hd__dfrtp_1
* cell instance sky130_fd_sc_hd__dfrtp_1_203 r0 *1 0,0
Xsky130_fd_sc_hd__dfrtp_1_203 osc_sel_clk u_cnt/_005_ cnt_o[22] rst_n VSS VDD
+ VDD sky130_fd_sc_hd__dfrtp_1
* cell instance sky130_fd_sc_hd__dfrtp_1_204 r0 *1 0,0
Xsky130_fd_sc_hd__dfrtp_1_204 osc_sel_clk u_cnt/_013_ tog_o rst_n VSS VDD VDD
+ sky130_fd_sc_hd__dfrtp_1
* cell instance sky130_fd_sc_hd__dfrtp_1_205 r0 *1 0,0
Xsky130_fd_sc_hd__dfrtp_1_205 clknet_leaf_16_clk_ref \_0271_ count_r[0][2]
+ rst_n VSS VDD VDD sky130_fd_sc_hd__dfrtp_1
* cell instance sky130_fd_sc_hd__dfrtp_1_206 r0 *1 0,0
Xsky130_fd_sc_hd__dfrtp_1_206 clknet_leaf_15_clk_ref \_0059_ count_r[3][2]
+ rst_n VSS VDD VDD sky130_fd_sc_hd__dfrtp_1
* cell instance sky130_fd_sc_hd__dfrtp_1_207 r0 *1 0,0
Xsky130_fd_sc_hd__dfrtp_1_207 clknet_leaf_16_clk_ref \_0156_ gate_cnt[30] rst_n
+ VSS VDD VDD sky130_fd_sc_hd__dfrtp_1
* cell instance sky130_fd_sc_hd__dfrtp_1_208 r0 *1 0,0
Xsky130_fd_sc_hd__dfrtp_1_208 clknet_leaf_17_clk_ref \_0168_ gate_cnt[18] rst_n
+ VSS VDD VDD sky130_fd_sc_hd__dfrtp_1
* cell instance sky130_fd_sc_hd__dfrtp_1_209 r0 *1 0,0
Xsky130_fd_sc_hd__dfrtp_1_209 clknet_leaf_24_clk_ref \_0120_ count_r[4][12]
+ rst_n VSS VDD VDD sky130_fd_sc_hd__dfrtp_1
* cell instance sky130_fd_sc_hd__dfrtp_1_210 r0 *1 0,0
Xsky130_fd_sc_hd__dfrtp_1_210 clknet_leaf_29_clk_ref \_0117_ count_r[4][15]
+ rst_n VSS VDD VDD sky130_fd_sc_hd__dfrtp_1
* cell instance sky130_fd_sc_hd__dfrtp_1_211 r0 *1 0,0
Xsky130_fd_sc_hd__dfrtp_1_211 osc_sel_clk u_cnt/_006_ cnt_o[21] rst_n VSS VDD
+ VDD sky130_fd_sc_hd__dfrtp_1
* cell instance sky130_fd_sc_hd__dfrtp_1_212 r0 *1 0,0
Xsky130_fd_sc_hd__dfrtp_1_212 osc_sel_clk u_cnt/_003_ cnt_o[1] rst_n VSS VDD
+ VDD sky130_fd_sc_hd__dfrtp_1
* cell instance sky130_fd_sc_hd__dfrtp_1_213 r0 *1 0,0
Xsky130_fd_sc_hd__dfrtp_1_213 clknet_leaf_24_clk_ref \_0034_ count_r[2][2]
+ rst_n VSS VDD VDD sky130_fd_sc_hd__dfrtp_1
* cell instance sky130_fd_sc_hd__dfrtp_1_214 r0 *1 0,0
Xsky130_fd_sc_hd__dfrtp_1_214 osc_sel_clk u_cnt/_009_ cnt_o[18] rst_n VSS VDD
+ VDD sky130_fd_sc_hd__dfrtp_1
* cell instance sky130_fd_sc_hd__dfrtp_1_215 r0 *1 0,0
Xsky130_fd_sc_hd__dfrtp_1_215 osc_sel_clk gate_en u_cnt/gate_s1 rst_n VSS VDD
+ VDD sky130_fd_sc_hd__dfrtp_1
* cell instance sky130_fd_sc_hd__dfrtp_1_216 r0 *1 0,0
Xsky130_fd_sc_hd__dfrtp_1_216 clknet_leaf_17_clk_ref \_0157_ gate_cnt[29] rst_n
+ VSS VDD VDD sky130_fd_sc_hd__dfrtp_1
* cell instance sky130_fd_sc_hd__dfrtp_1_217 r0 *1 0,0
Xsky130_fd_sc_hd__dfrtp_1_217 clknet_leaf_18_clk_ref \_0167_ gate_cnt[19] rst_n
+ VSS VDD VDD sky130_fd_sc_hd__dfrtp_1
* cell instance sky130_fd_sc_hd__dfrtp_1_218 r0 *1 0,0
Xsky130_fd_sc_hd__dfrtp_1_218 clknet_leaf_29_clk_ref \_0069_ count_r[1][15]
+ rst_n VSS VDD VDD sky130_fd_sc_hd__dfrtp_1
* cell instance sky130_fd_sc_hd__dfrtp_1_219 r0 *1 0,0
Xsky130_fd_sc_hd__dfrtp_1_219 clknet_leaf_31_clk_ref \_0021_ count_r[2][15]
+ rst_n VSS VDD VDD sky130_fd_sc_hd__dfrtp_1
* cell instance sky130_fd_sc_hd__dfrtp_1_220 r0 *1 0,0
Xsky130_fd_sc_hd__dfrtp_1_220 clknet_leaf_24_clk_ref \_0261_ count_r[0][10]
+ rst_n VSS VDD VDD sky130_fd_sc_hd__dfrtp_1
* cell instance sky130_fd_sc_hd__dfrtp_1_221 r0 *1 0,0
Xsky130_fd_sc_hd__dfrtp_1_221 osc_sel_clk u_cnt/_025_ ovf_o rst_n VSS VDD VDD
+ sky130_fd_sc_hd__dfrtp_1
* cell instance sky130_fd_sc_hd__dfrtp_1_222 r0 *1 0,0
Xsky130_fd_sc_hd__dfrtp_1_222 osc_sel_clk u_cnt/_007_ cnt_o[20] rst_n VSS VDD
+ VDD sky130_fd_sc_hd__dfrtp_1
* cell instance sky130_fd_sc_hd__dfrtp_1_223 r0 *1 0,0
Xsky130_fd_sc_hd__dfrtp_1_223 clknet_leaf_17_clk_ref \_0219_ gate_cnt[31] rst_n
+ VSS VDD VDD sky130_fd_sc_hd__dfrtp_1
* cell instance sky130_fd_sc_hd__dfrtp_1_224 r0 *1 0,0
Xsky130_fd_sc_hd__dfrtp_1_224 clknet_leaf_29_clk_ref \_0256_ count_r[0][15]
+ rst_n VSS VDD VDD sky130_fd_sc_hd__dfrtp_1
* cell instance sky130_fd_sc_hd__dfrtp_1_225 r0 *1 0,0
Xsky130_fd_sc_hd__dfrtp_1_225 clknet_leaf_23_clk_ref \_0125_ count_r[4][7]
+ rst_n VSS VDD VDD sky130_fd_sc_hd__dfrtp_1
* cell instance sky130_fd_sc_hd__dfrtp_1_226 r0 *1 0,0
Xsky130_fd_sc_hd__dfrtp_1_226 osc_sel_clk u_cnt/_004_ cnt_o[0] rst_n VSS VDD
+ VDD sky130_fd_sc_hd__dfrtp_1
* cell instance sky130_fd_sc_hd__dfrtp_1_227 r0 *1 0,0
Xsky130_fd_sc_hd__dfrtp_1_227 clknet_leaf_23_clk_ref \_0077_ count_r[1][7]
+ rst_n VSS VDD VDD sky130_fd_sc_hd__dfrtp_1
* cell instance sky130_fd_sc_hd__dfrtp_1_228 r0 *1 0,0
Xsky130_fd_sc_hd__dfrtp_1_228 osc_sel_clk u_cnt/_010_ cnt_o[17] rst_n VSS VDD
+ VDD sky130_fd_sc_hd__dfrtp_1
* cell instance sky130_fd_sc_hd__dfrtp_1_229 r0 *1 0,0
Xsky130_fd_sc_hd__dfrtp_1_229 clknet_leaf_17_clk_ref \_0185_ gate_cnt[1] rst_n
+ VSS VDD VDD sky130_fd_sc_hd__dfrtp_1
* cell instance sky130_fd_sc_hd__dfrtp_1_230 r0 *1 0,0
Xsky130_fd_sc_hd__dfrtp_1_230 clknet_leaf_29_clk_ref \_0065_ count_r[1][19]
+ rst_n VSS VDD VDD sky130_fd_sc_hd__dfrtp_1
* cell instance sky130_fd_sc_hd__dfrtp_1_231 r0 *1 0,0
Xsky130_fd_sc_hd__dfrtp_1_231 clknet_leaf_28_clk_ref \_0017_ count_r[2][19]
+ rst_n VSS VDD VDD sky130_fd_sc_hd__dfrtp_1
* cell instance sky130_fd_sc_hd__dfrtp_1_232 r0 *1 0,0
Xsky130_fd_sc_hd__dfrtp_1_232 osc_sel_clk u_cnt/gate_s1 u_cnt/gate_s2 rst_n VSS
+ VDD VDD sky130_fd_sc_hd__dfrtp_1
* cell instance sky130_fd_sc_hd__dfrtp_1_233 r0 *1 0,0
Xsky130_fd_sc_hd__dfrtp_1_233 osc_sel_clk u_cnt/_002_ cnt_o[2] rst_n VSS VDD
+ VDD sky130_fd_sc_hd__dfrtp_1
* cell instance sky130_fd_sc_hd__dfrtp_1_234 r0 *1 0,0
Xsky130_fd_sc_hd__dfrtp_1_234 clknet_leaf_23_clk_ref \_0029_ count_r[2][7]
+ rst_n VSS VDD VDD sky130_fd_sc_hd__dfrtp_1
* cell instance sky130_fd_sc_hd__dfrtp_1_235 r0 *1 0,0
Xsky130_fd_sc_hd__dfrtp_1_235 clknet_leaf_18_clk_ref \_0169_ gate_cnt[17] rst_n
+ VSS VDD VDD sky130_fd_sc_hd__dfrtp_1
* cell instance sky130_fd_sc_hd__dfrtp_1_236 r0 *1 0,0
Xsky130_fd_sc_hd__dfrtp_1_236 clknet_leaf_29_clk_ref \_0113_ count_r[4][19]
+ rst_n VSS VDD VDD sky130_fd_sc_hd__dfrtp_1
* cell instance sky130_fd_sc_hd__dfrtp_1_237 r0 *1 0,0
Xsky130_fd_sc_hd__dfrtp_1_237 osc_sel_clk u_cnt/_008_ cnt_o[19] rst_n VSS VDD
+ VDD sky130_fd_sc_hd__dfrtp_1
* cell instance sky130_fd_sc_hd__dfrtp_1_238 r0 *1 0,0
Xsky130_fd_sc_hd__dfrtp_1_238 clknet_leaf_29_clk_ref \_0042_ count_r[3][19]
+ rst_n VSS VDD VDD sky130_fd_sc_hd__dfrtp_1
* cell instance sky130_fd_sc_hd__dfrtp_1_239 r0 *1 0,0
Xsky130_fd_sc_hd__dfrtp_1_239 osc_sel_clk u_cnt/gate_s2 u_cnt/running rst_n VSS
+ VDD VDD sky130_fd_sc_hd__dfrtp_1
* cell instance sky130_fd_sc_hd__dfrtp_1_240 r0 *1 0,0
Xsky130_fd_sc_hd__dfrtp_1_240 clknet_leaf_23_clk_ref \_0158_ gate_cnt[28] rst_n
+ VSS VDD VDD sky130_fd_sc_hd__dfrtp_1
* cell instance sky130_fd_sc_hd__dfrtp_1_241 r0 *1 0,0
Xsky130_fd_sc_hd__dfrtp_1_241 osc_sel_clk u_cnt/_016_ cnt_o[23] rst_n VSS VDD
+ VDD sky130_fd_sc_hd__dfrtp_1
* cell instance sky130_fd_sc_hd__dfrtp_1_242 r0 *1 0,0
Xsky130_fd_sc_hd__dfrtp_1_242 clknet_leaf_23_clk_ref \_0055_ count_r[3][6]
+ rst_n VSS VDD VDD sky130_fd_sc_hd__dfrtp_1
* cell instance sky130_fd_sc_hd__dfrtp_1_243 r0 *1 0,0
Xsky130_fd_sc_hd__dfrtp_1_243 clknet_leaf_28_clk_ref \_0262_ count_r[4][23]
+ rst_n VSS VDD VDD sky130_fd_sc_hd__dfrtp_1
* cell instance sky130_fd_sc_hd__dfrtp_1_244 r0 *1 0,0
Xsky130_fd_sc_hd__dfrtp_1_244 osc_sel_clk u_cnt/_017_ cnt_o[12] rst_n VSS VDD
+ VDD sky130_fd_sc_hd__dfrtp_1
* cell instance sky130_fd_sc_hd__dfrtp_1_245 r0 *1 0,0
Xsky130_fd_sc_hd__dfrtp_1_245 osc_sel_clk u_cnt/_022_ cnt_o[7] rst_n VSS VDD
+ VDD sky130_fd_sc_hd__dfrtp_1
* cell instance sky130_fd_sc_hd__dfrtp_1_246 r0 *1 0,0
Xsky130_fd_sc_hd__dfrtp_1_246 clknet_leaf_23_clk_ref \_0054_ count_r[3][7]
+ rst_n VSS VDD VDD sky130_fd_sc_hd__dfrtp_1
* cell instance sky130_fd_sc_hd__dfrtp_1_247 r0 *1 0,0
Xsky130_fd_sc_hd__dfrtp_1_247 clknet_leaf_18_clk_ref \_0170_ gate_cnt[16] rst_n
+ VSS VDD VDD sky130_fd_sc_hd__dfrtp_1
* cell instance sky130_fd_sc_hd__dfrtp_1_248 r0 *1 0,0
Xsky130_fd_sc_hd__dfrtp_1_248 clknet_leaf_23_clk_ref \_0126_ count_r[4][6]
+ rst_n VSS VDD VDD sky130_fd_sc_hd__dfrtp_1
* cell instance sky130_fd_sc_hd__dfrtp_1_249 r0 *1 0,0
Xsky130_fd_sc_hd__dfrtp_1_249 osc_sel_clk u_cnt/_019_ cnt_o[10] rst_n VSS VDD
+ VDD sky130_fd_sc_hd__dfrtp_1
* cell instance sky130_fd_sc_hd__dfrtp_1_250 r0 *1 0,0
Xsky130_fd_sc_hd__dfrtp_1_250 osc_sel_clk u_cnt/_011_ cnt_o[16] rst_n VSS VDD
+ VDD sky130_fd_sc_hd__dfrtp_1
* cell instance sky130_fd_sc_hd__dfrtp_1_251 r0 *1 0,0
Xsky130_fd_sc_hd__dfrtp_1_251 clknet_leaf_20_clk_ref \_0184_ gate_cnt[2] rst_n
+ VSS VDD VDD sky130_fd_sc_hd__dfrtp_1
* cell instance sky130_fd_sc_hd__dfrtp_1_252 r0 *1 0,0
Xsky130_fd_sc_hd__dfrtp_1_252 clknet_leaf_23_clk_ref \_0186_ gate_cnt[0] rst_n
+ VSS VDD VDD sky130_fd_sc_hd__dfrtp_1
* cell instance sky130_fd_sc_hd__dfrtp_1_253 r0 *1 0,0
Xsky130_fd_sc_hd__dfrtp_1_253 clknet_leaf_22_clk_ref \_0265_ count_r[0][7]
+ rst_n VSS VDD VDD sky130_fd_sc_hd__dfrtp_1
* cell instance sky130_fd_sc_hd__dfrtp_1_254 r0 *1 0,0
Xsky130_fd_sc_hd__dfrtp_1_254 osc_sel_clk u_cnt/_023_ cnt_o[6] rst_n VSS VDD
+ VDD sky130_fd_sc_hd__dfrtp_1
* cell instance sky130_fd_sc_hd__dfrtp_1_255 r0 *1 0,0
Xsky130_fd_sc_hd__dfrtp_1_255 clknet_leaf_22_clk_ref \_0078_ count_r[1][6]
+ rst_n VSS VDD VDD sky130_fd_sc_hd__dfrtp_1
* cell instance sky130_fd_sc_hd__dfrtp_1_256 r0 *1 0,0
Xsky130_fd_sc_hd__dfrtp_1_256 clknet_leaf_28_clk_ref \_0252_ count_r[0][19]
+ rst_n VSS VDD VDD sky130_fd_sc_hd__dfrtp_1
* cell instance sky130_fd_sc_hd__dfrtp_1_257 r0 *1 0,0
Xsky130_fd_sc_hd__dfrtp_1_257 osc_sel_clk u_cnt/_012_ cnt_o[15] rst_n VSS VDD
+ VDD sky130_fd_sc_hd__dfrtp_1
* cell instance sky130_fd_sc_hd__dfrtp_1_258 r0 *1 0,0
Xsky130_fd_sc_hd__dfrtp_1_258 clknet_leaf_28_clk_ref \_0209_ count_r[0][23]
+ rst_n VSS VDD VDD sky130_fd_sc_hd__dfrtp_1
* cell instance sky130_fd_sc_hd__dfrtp_1_259 r0 *1 0,0
Xsky130_fd_sc_hd__dfrtp_1_259 osc_sel_clk u_cnt/_014_ cnt_o[14] rst_n VSS VDD
+ VDD sky130_fd_sc_hd__dfrtp_1
* cell instance sky130_fd_sc_hd__dfrtp_1_260 r0 *1 0,0
Xsky130_fd_sc_hd__dfrtp_1_260 clknet_leaf_18_clk_ref \_0180_ gate_cnt[6] rst_n
+ VSS VDD VDD sky130_fd_sc_hd__dfrtp_1
* cell instance sky130_fd_sc_hd__dfrtp_1_261 r0 *1 0,0
Xsky130_fd_sc_hd__dfrtp_1_261 clknet_leaf_22_clk_ref \_0058_ count_r[3][3]
+ rst_n VSS VDD VDD sky130_fd_sc_hd__dfrtp_1
* cell instance sky130_fd_sc_hd__dfrtp_1_262 r0 *1 0,0
Xsky130_fd_sc_hd__dfrtp_1_262 clknet_leaf_18_clk_ref \_0179_ gate_cnt[7] rst_n
+ VSS VDD VDD sky130_fd_sc_hd__dfrtp_1
* cell instance sky130_fd_sc_hd__dfrtp_1_263 r0 *1 0,0
Xsky130_fd_sc_hd__dfrtp_1_263 clknet_leaf_22_clk_ref \_0081_ count_r[1][3]
+ rst_n VSS VDD VDD sky130_fd_sc_hd__dfrtp_1
* cell instance sky130_fd_sc_hd__dfrtp_1_264 r0 *1 0,0
Xsky130_fd_sc_hd__dfrtp_1_264 clknet_leaf_20_clk_ref \_0177_ gate_cnt[9] rst_n
+ VSS VDD VDD sky130_fd_sc_hd__dfrtp_1
* cell instance sky130_fd_sc_hd__dfrtp_1_265 r0 *1 0,0
Xsky130_fd_sc_hd__dfrtp_1_265 clknet_leaf_26_clk_ref \_0201_ count_r[1][23]
+ rst_n VSS VDD VDD sky130_fd_sc_hd__dfrtp_1
* cell instance sky130_fd_sc_hd__dfrtp_1_266 r0 *1 0,0
Xsky130_fd_sc_hd__dfrtp_1_266 clknet_leaf_22_clk_ref \_0266_ count_r[0][6]
+ rst_n VSS VDD VDD sky130_fd_sc_hd__dfrtp_1
* cell instance sky130_fd_sc_hd__dfrtp_1_267 r0 *1 0,0
Xsky130_fd_sc_hd__dfrtp_1_267 clknet_leaf_18_clk_ref \_0178_ gate_cnt[8] rst_n
+ VSS VDD VDD sky130_fd_sc_hd__dfrtp_1
* cell instance sky130_fd_sc_hd__dfrtp_1_268 r0 *1 0,0
Xsky130_fd_sc_hd__dfrtp_1_268 osc_sel_clk u_cnt/_021_ cnt_o[8] rst_n VSS VDD
+ VDD sky130_fd_sc_hd__dfrtp_1
* cell instance sky130_fd_sc_hd__dfrtp_1_269 r0 *1 0,0
Xsky130_fd_sc_hd__dfrtp_1_269 clknet_leaf_20_clk_ref \_0181_ gate_cnt[5] rst_n
+ VSS VDD VDD sky130_fd_sc_hd__dfrtp_1
* cell instance sky130_fd_sc_hd__dfrtp_1_270 r0 *1 0,0
Xsky130_fd_sc_hd__dfrtp_1_270 clknet_leaf_26_clk_ref \_0075_ count_r[1][9]
+ rst_n VSS VDD VDD sky130_fd_sc_hd__dfrtp_1
* cell instance sky130_fd_sc_hd__dfrtp_1_271 r0 *1 0,0
Xsky130_fd_sc_hd__dfrtp_1_271 osc_sel_clk u_cnt/_018_ cnt_o[11] rst_n VSS VDD
+ VDD sky130_fd_sc_hd__dfrtp_1
* cell instance sky130_fd_sc_hd__dfrtp_1_272 r0 *1 0,0
Xsky130_fd_sc_hd__dfrtp_1_272 osc_sel_clk u_cnt/_020_ cnt_o[9] rst_n VSS VDD
+ VDD sky130_fd_sc_hd__dfrtp_1
* cell instance sky130_fd_sc_hd__dfrtp_1_273 r0 *1 0,0
Xsky130_fd_sc_hd__dfrtp_1_273 clknet_leaf_22_clk_ref \_0030_ count_r[2][6]
+ rst_n VSS VDD VDD sky130_fd_sc_hd__dfrtp_1
* cell instance sky130_fd_sc_hd__dfrtp_1_274 r0 *1 0,0
Xsky130_fd_sc_hd__dfrtp_1_274 clknet_leaf_22_clk_ref \_0269_ count_r[0][3]
+ rst_n VSS VDD VDD sky130_fd_sc_hd__dfrtp_1
* cell instance sky130_fd_sc_hd__dfrtp_1_275 r0 *1 0,0
Xsky130_fd_sc_hd__dfrtp_1_275 osc_sel_clk u_cnt/_001_ cnt_o[3] rst_n VSS VDD
+ VDD sky130_fd_sc_hd__dfrtp_1
* cell instance sky130_fd_sc_hd__dfrtp_1_276 r0 *1 0,0
Xsky130_fd_sc_hd__dfrtp_1_276 clknet_leaf_26_clk_ref \_0205_ count_r[2][23]
+ rst_n VSS VDD VDD sky130_fd_sc_hd__dfrtp_1
* cell instance sky130_fd_sc_hd__dfrtp_1_277 r0 *1 0,0
Xsky130_fd_sc_hd__dfrtp_1_277 clknet_leaf_20_clk_ref \_0183_ gate_cnt[3] rst_n
+ VSS VDD VDD sky130_fd_sc_hd__dfrtp_1
* cell instance sky130_fd_sc_hd__dfrtp_1_278 r0 *1 0,0
Xsky130_fd_sc_hd__dfrtp_1_278 clknet_leaf_19_clk_ref \_0176_ gate_cnt[10] rst_n
+ VSS VDD VDD sky130_fd_sc_hd__dfrtp_1
* cell instance sky130_fd_sc_hd__dfrtp_1_279 r0 *1 0,0
Xsky130_fd_sc_hd__dfrtp_1_279 clknet_leaf_28_clk_ref \_0258_ count_r[0][13]
+ rst_n VSS VDD VDD sky130_fd_sc_hd__dfrtp_1
* cell instance sky130_fd_sc_hd__dfrtp_1_280 r0 *1 0,0
Xsky130_fd_sc_hd__dfrtp_1_280 osc_sel_clk u_cnt/_015_ cnt_o[13] rst_n VSS VDD
+ VDD sky130_fd_sc_hd__dfrtp_1
* cell instance sky130_fd_sc_hd__dfrtp_1_281 r0 *1 0,0
Xsky130_fd_sc_hd__dfrtp_1_281 clknet_leaf_27_clk_ref \_0203_ count_r[3][23]
+ rst_n VSS VDD VDD sky130_fd_sc_hd__dfrtp_1
* cell instance sky130_fd_sc_hd__dfrtp_1_282 r0 *1 0,0
Xsky130_fd_sc_hd__dfrtp_1_282 clknet_leaf_21_clk_ref \_0129_ count_r[4][3]
+ rst_n VSS VDD VDD sky130_fd_sc_hd__dfrtp_1
* cell instance sky130_fd_sc_hd__dfrtp_1_283 r0 *1 0,0
Xsky130_fd_sc_hd__dfrtp_1_283 clknet_leaf_26_clk_ref \_0050_ count_r[3][11]
+ rst_n VSS VDD VDD sky130_fd_sc_hd__dfrtp_1
* cell instance sky130_fd_sc_hd__dfrtp_1_284 r0 *1 0,0
Xsky130_fd_sc_hd__dfrtp_1_284 clknet_leaf_25_clk_ref \_0056_ count_r[3][5]
+ rst_n VSS VDD VDD sky130_fd_sc_hd__dfrtp_1
* cell instance sky130_fd_sc_hd__dfrtp_1_285 r0 *1 0,0
Xsky130_fd_sc_hd__dfrtp_1_285 osc_sel_clk u_cnt/_024_ cnt_o[5] rst_n VSS VDD
+ VDD sky130_fd_sc_hd__dfrtp_1
* cell instance sky130_fd_sc_hd__dfrtp_1_286 r0 *1 0,0
Xsky130_fd_sc_hd__dfrtp_1_286 osc_sel_clk u_cnt/_000_ cnt_o[4] rst_n VSS VDD
+ VDD sky130_fd_sc_hd__dfrtp_1
* cell instance sky130_fd_sc_hd__dfrtp_1_287 r0 *1 0,0
Xsky130_fd_sc_hd__dfrtp_1_287 clknet_leaf_21_clk_ref \_0033_ count_r[2][3]
+ rst_n VSS VDD VDD sky130_fd_sc_hd__dfrtp_1
* cell instance sky130_fd_sc_hd__dfrtp_1_288 r0 *1 0,0
Xsky130_fd_sc_hd__dfrtp_1_288 clknet_leaf_20_clk_ref \_0053_ count_r[3][8]
+ rst_n VSS VDD VDD sky130_fd_sc_hd__dfrtp_1
* cell instance sky130_fd_sc_hd__dfrtp_1_289 r0 *1 0,0
Xsky130_fd_sc_hd__dfrtp_1_289 clknet_leaf_19_clk_ref \_0182_ gate_cnt[4] rst_n
+ VSS VDD VDD sky130_fd_sc_hd__dfrtp_1
* cell instance sky130_fd_sc_hd__dfrtp_1_290 r0 *1 0,0
Xsky130_fd_sc_hd__dfrtp_1_290 clknet_leaf_26_clk_ref \_0052_ count_r[3][9]
+ rst_n VSS VDD VDD sky130_fd_sc_hd__dfrtp_1
* cell instance sky130_fd_sc_hd__dfrtp_1_291 r0 *1 0,0
Xsky130_fd_sc_hd__dfrtp_1_291 clknet_leaf_19_clk_ref \_0171_ gate_cnt[15] rst_n
+ VSS VDD VDD sky130_fd_sc_hd__dfrtp_1
* cell instance sky130_fd_sc_hd__dfrtp_1_292 r0 *1 0,0
Xsky130_fd_sc_hd__dfrtp_1_292 clknet_leaf_21_clk_ref \_0057_ count_r[3][4]
+ rst_n VSS VDD VDD sky130_fd_sc_hd__dfrtp_1
* cell instance sky130_fd_sc_hd__dfrtp_1_293 r0 *1 0,0
Xsky130_fd_sc_hd__dfrtp_1_293 clknet_leaf_28_clk_ref \_0071_ count_r[1][13]
+ rst_n VSS VDD VDD sky130_fd_sc_hd__dfrtp_1
* cell instance sky130_fd_sc_hd__dfrtp_1_294 r0 *1 0,0
Xsky130_fd_sc_hd__dfrtp_1_294 clknet_leaf_26_clk_ref \_0027_ count_r[2][9]
+ rst_n VSS VDD VDD sky130_fd_sc_hd__dfrtp_1
* cell instance sky130_fd_sc_hd__dfrtp_1_295 r0 *1 0,0
Xsky130_fd_sc_hd__dfrtp_1_295 clknet_leaf_27_clk_ref \_0048_ count_r[3][13]
+ rst_n VSS VDD VDD sky130_fd_sc_hd__dfrtp_1
* cell instance sky130_fd_sc_hd__dfrtp_1_296 r0 *1 0,0
Xsky130_fd_sc_hd__dfrtp_1_296 clknet_leaf_19_clk_ref \_0173_ gate_cnt[13] rst_n
+ VSS VDD VDD sky130_fd_sc_hd__dfrtp_1
* cell instance sky130_fd_sc_hd__dfrtp_1_297 r0 *1 0,0
Xsky130_fd_sc_hd__dfrtp_1_297 clknet_leaf_27_clk_ref \_0023_ count_r[2][13]
+ rst_n VSS VDD VDD sky130_fd_sc_hd__dfrtp_1
* cell instance sky130_fd_sc_hd__dfrtp_1_298 r0 *1 0,0
Xsky130_fd_sc_hd__dfrtp_1_298 clknet_leaf_27_clk_ref \_0025_ count_r[2][11]
+ rst_n VSS VDD VDD sky130_fd_sc_hd__dfrtp_1
* cell instance sky130_fd_sc_hd__dfrtp_1_299 r0 *1 0,0
Xsky130_fd_sc_hd__dfrtp_1_299 clknet_leaf_25_clk_ref \_0031_ count_r[2][5]
+ rst_n VSS VDD VDD sky130_fd_sc_hd__dfrtp_1
* cell instance sky130_fd_sc_hd__dfrtp_1_300 r0 *1 0,0
Xsky130_fd_sc_hd__dfrtp_1_300 clknet_leaf_19_clk_ref \_0172_ gate_cnt[14] rst_n
+ VSS VDD VDD sky130_fd_sc_hd__dfrtp_1
* cell instance sky130_fd_sc_hd__dfrtp_1_301 r0 *1 0,0
Xsky130_fd_sc_hd__dfrtp_1_301 clknet_leaf_19_clk_ref \_0175_ gate_cnt[11] rst_n
+ VSS VDD VDD sky130_fd_sc_hd__dfrtp_1
* cell instance sky130_fd_sc_hd__dfrtp_1_302 r0 *1 0,0
Xsky130_fd_sc_hd__dfrtp_1_302 clknet_leaf_25_clk_ref \_0032_ count_r[2][4]
+ rst_n VSS VDD VDD sky130_fd_sc_hd__dfrtp_1
* cell instance sky130_fd_sc_hd__dfrtp_1_303 r0 *1 0,0
Xsky130_fd_sc_hd__dfrtp_1_303 clknet_leaf_21_clk_ref \_0028_ count_r[2][8]
+ rst_n VSS VDD VDD sky130_fd_sc_hd__dfrtp_1
* cell instance sky130_fd_sc_hd__dfrtp_1_304 r0 *1 0,0
Xsky130_fd_sc_hd__dfrtp_1_304 clknet_leaf_19_clk_ref \_0174_ gate_cnt[12] rst_n
+ VSS VDD VDD sky130_fd_sc_hd__dfrtp_1
* cell instance sky130_fd_sc_hd__dfrtp_1_305 r0 *1 0,0
Xsky130_fd_sc_hd__dfrtp_1_305 clknet_leaf_27_clk_ref \_0119_ count_r[4][13]
+ rst_n VSS VDD VDD sky130_fd_sc_hd__dfrtp_1
* cell instance sky130_fd_sc_hd__dfrtp_1_306 r0 *1 0,0
Xsky130_fd_sc_hd__dfrtp_1_306 clknet_leaf_25_clk_ref \_0127_ count_r[4][5]
+ rst_n VSS VDD VDD sky130_fd_sc_hd__dfrtp_1
* cell instance sky130_fd_sc_hd__dfrtp_1_307 r0 *1 0,0
Xsky130_fd_sc_hd__dfrtp_1_307 clknet_leaf_20_clk_ref \_0124_ count_r[4][8]
+ rst_n VSS VDD VDD sky130_fd_sc_hd__dfrtp_1
* cell instance sky130_fd_sc_hd__dfrtp_1_308 r0 *1 0,0
Xsky130_fd_sc_hd__dfrtp_1_308 clknet_leaf_27_clk_ref \_0121_ count_r[4][11]
+ rst_n VSS VDD VDD sky130_fd_sc_hd__dfrtp_1
* cell instance sky130_fd_sc_hd__dfrtp_1_309 r0 *1 0,0
Xsky130_fd_sc_hd__dfrtp_1_309 clknet_leaf_26_clk_ref \_0123_ count_r[4][9]
+ rst_n VSS VDD VDD sky130_fd_sc_hd__dfrtp_1
* cell instance sky130_fd_sc_hd__dfrtp_1_310 r0 *1 0,0
Xsky130_fd_sc_hd__dfrtp_1_310 clknet_leaf_21_clk_ref \_0264_ count_r[0][8]
+ rst_n VSS VDD VDD sky130_fd_sc_hd__dfrtp_1
* cell instance sky130_fd_sc_hd__dfrtp_1_311 r0 *1 0,0
Xsky130_fd_sc_hd__dfrtp_1_311 clknet_leaf_27_clk_ref \_0073_ count_r[1][11]
+ rst_n VSS VDD VDD sky130_fd_sc_hd__dfrtp_1
* cell instance sky130_fd_sc_hd__dfrtp_1_312 r0 *1 0,0
Xsky130_fd_sc_hd__dfrtp_1_312 clknet_leaf_25_clk_ref \_0260_ count_r[0][11]
+ rst_n VSS VDD VDD sky130_fd_sc_hd__dfrtp_1
* cell instance sky130_fd_sc_hd__dfrtp_1_313 r0 *1 0,0
Xsky130_fd_sc_hd__dfrtp_1_313 clknet_leaf_21_clk_ref \_0076_ count_r[1][8]
+ rst_n VSS VDD VDD sky130_fd_sc_hd__dfrtp_1
* cell instance sky130_fd_sc_hd__dfrtp_1_314 r0 *1 0,0
Xsky130_fd_sc_hd__dfrtp_1_314 clknet_leaf_25_clk_ref \_0079_ count_r[1][5]
+ rst_n VSS VDD VDD sky130_fd_sc_hd__dfrtp_1
* cell instance sky130_fd_sc_hd__dfrtp_1_315 r0 *1 0,0
Xsky130_fd_sc_hd__dfrtp_1_315 clknet_leaf_25_clk_ref \_0267_ count_r[0][5]
+ rst_n VSS VDD VDD sky130_fd_sc_hd__dfrtp_1
* cell instance sky130_fd_sc_hd__dfrtp_1_316 r0 *1 0,0
Xsky130_fd_sc_hd__dfrtp_1_316 clknet_leaf_25_clk_ref \_0080_ count_r[1][4]
+ rst_n VSS VDD VDD sky130_fd_sc_hd__dfrtp_1
* cell instance sky130_fd_sc_hd__dfrtp_1_317 r0 *1 0,0
Xsky130_fd_sc_hd__dfrtp_1_317 clknet_leaf_21_clk_ref \_0128_ count_r[4][4]
+ rst_n VSS VDD VDD sky130_fd_sc_hd__dfrtp_1
* cell instance sky130_fd_sc_hd__dfrtp_1_318 r0 *1 0,0
Xsky130_fd_sc_hd__dfrtp_1_318 clknet_leaf_26_clk_ref \_0263_ count_r[0][9]
+ rst_n VSS VDD VDD sky130_fd_sc_hd__dfrtp_1
* cell instance sky130_fd_sc_hd__dfrtp_1_319 r0 *1 0,0
Xsky130_fd_sc_hd__dfrtp_1_319 clknet_leaf_21_clk_ref \_0268_ count_r[0][4]
+ rst_n VSS VDD VDD sky130_fd_sc_hd__dfrtp_1
* cell instance sky130_fd_sc_hd__dfstp_2_0 r0 *1 0,0
Xsky130_fd_sc_hd__dfstp_2_0 clknet_leaf_1_clk_ref \_0276_ ctrl_k[1] rst_n VSS
+ VDD VDD sky130_fd_sc_hd__dfstp_2
* cell instance sky130_fd_sc_hd__dfstp_2_1 r0 *1 0,0
Xsky130_fd_sc_hd__dfstp_2_1 clknet_leaf_4_clk_ref \_0274_ ctrl_k[3] rst_n VSS
+ VDD VDD sky130_fd_sc_hd__dfstp_2
* cell instance sky130_fd_sc_hd__dfstp_2_2 r0 *1 0,0
Xsky130_fd_sc_hd__dfstp_2_2 clknet_leaf_12_clk_ref \_0278_ k_q[3] rst_n VSS VDD
+ VDD sky130_fd_sc_hd__dfstp_2
* cell instance sky130_fd_sc_hd__dfstp_2_3 r0 *1 0,0
Xsky130_fd_sc_hd__dfstp_2_3 clknet_leaf_16_clk_ref \_0280_ k_q[1] rst_n VSS VDD
+ VDD sky130_fd_sc_hd__dfstp_2
* cell instance sky130_fd_sc_hd__diode_2_0 r0 *1 0,0
Xsky130_fd_sc_hd__diode_2_0 osc[3] VSS VDD VDD sky130_fd_sc_hd__diode_2
* cell instance sky130_fd_sc_hd__diode_2_1 r0 *1 0,0
Xsky130_fd_sc_hd__diode_2_1 clk_ref VSS VDD VDD sky130_fd_sc_hd__diode_2
* cell instance sky130_fd_sc_hd__fill_1_0 r0 *1 0,0
Xsky130_fd_sc_hd__fill_1_0 VSS VDD VDD sky130_fd_sc_hd__fill_1
* cell instance sky130_fd_sc_hd__fill_1_1 r0 *1 0,0
Xsky130_fd_sc_hd__fill_1_1 VSS VDD VDD sky130_fd_sc_hd__fill_1
* cell instance sky130_fd_sc_hd__fill_1_2 r0 *1 0,0
Xsky130_fd_sc_hd__fill_1_2 VSS VDD VDD sky130_fd_sc_hd__fill_1
* cell instance sky130_fd_sc_hd__fill_1_3 r0 *1 0,0
Xsky130_fd_sc_hd__fill_1_3 VSS VDD VDD sky130_fd_sc_hd__fill_1
* cell instance sky130_fd_sc_hd__fill_1_4 r0 *1 0,0
Xsky130_fd_sc_hd__fill_1_4 VSS VDD VDD sky130_fd_sc_hd__fill_1
* cell instance sky130_fd_sc_hd__fill_1_5 r0 *1 0,0
Xsky130_fd_sc_hd__fill_1_5 VSS VDD VDD sky130_fd_sc_hd__fill_1
* cell instance sky130_fd_sc_hd__fill_1_6 r0 *1 0,0
Xsky130_fd_sc_hd__fill_1_6 VSS VDD VDD sky130_fd_sc_hd__fill_1
* cell instance sky130_fd_sc_hd__fill_1_7 r0 *1 0,0
Xsky130_fd_sc_hd__fill_1_7 VSS VDD VDD sky130_fd_sc_hd__fill_1
* cell instance sky130_fd_sc_hd__fill_1_8 r0 *1 0,0
Xsky130_fd_sc_hd__fill_1_8 VSS VDD VDD sky130_fd_sc_hd__fill_1
* cell instance sky130_fd_sc_hd__fill_1_9 r0 *1 0,0
Xsky130_fd_sc_hd__fill_1_9 VSS VDD VDD sky130_fd_sc_hd__fill_1
* cell instance sky130_fd_sc_hd__fill_1_10 r0 *1 0,0
Xsky130_fd_sc_hd__fill_1_10 VSS VDD VDD sky130_fd_sc_hd__fill_1
* cell instance sky130_fd_sc_hd__fill_1_11 r0 *1 0,0
Xsky130_fd_sc_hd__fill_1_11 VSS VDD VDD sky130_fd_sc_hd__fill_1
* cell instance sky130_fd_sc_hd__fill_1_12 r0 *1 0,0
Xsky130_fd_sc_hd__fill_1_12 VSS VDD VDD sky130_fd_sc_hd__fill_1
* cell instance sky130_fd_sc_hd__fill_1_13 r0 *1 0,0
Xsky130_fd_sc_hd__fill_1_13 VSS VDD VDD sky130_fd_sc_hd__fill_1
* cell instance sky130_fd_sc_hd__fill_1_14 r0 *1 0,0
Xsky130_fd_sc_hd__fill_1_14 VSS VDD VDD sky130_fd_sc_hd__fill_1
* cell instance sky130_fd_sc_hd__fill_1_15 r0 *1 0,0
Xsky130_fd_sc_hd__fill_1_15 VSS VDD VDD sky130_fd_sc_hd__fill_1
* cell instance sky130_fd_sc_hd__fill_1_16 r0 *1 0,0
Xsky130_fd_sc_hd__fill_1_16 VSS VDD VDD sky130_fd_sc_hd__fill_1
* cell instance sky130_fd_sc_hd__fill_1_17 r0 *1 0,0
Xsky130_fd_sc_hd__fill_1_17 VSS VDD VDD sky130_fd_sc_hd__fill_1
* cell instance sky130_fd_sc_hd__fill_1_18 r0 *1 0,0
Xsky130_fd_sc_hd__fill_1_18 VSS VDD VDD sky130_fd_sc_hd__fill_1
* cell instance sky130_fd_sc_hd__fill_1_19 r0 *1 0,0
Xsky130_fd_sc_hd__fill_1_19 VSS VDD VDD sky130_fd_sc_hd__fill_1
* cell instance sky130_fd_sc_hd__fill_1_20 r0 *1 0,0
Xsky130_fd_sc_hd__fill_1_20 VSS VDD VDD sky130_fd_sc_hd__fill_1
* cell instance sky130_fd_sc_hd__fill_1_21 r0 *1 0,0
Xsky130_fd_sc_hd__fill_1_21 VSS VDD VDD sky130_fd_sc_hd__fill_1
* cell instance sky130_fd_sc_hd__fill_1_22 r0 *1 0,0
Xsky130_fd_sc_hd__fill_1_22 VSS VDD VDD sky130_fd_sc_hd__fill_1
* cell instance sky130_fd_sc_hd__fill_1_23 r0 *1 0,0
Xsky130_fd_sc_hd__fill_1_23 VSS VDD VDD sky130_fd_sc_hd__fill_1
* cell instance sky130_fd_sc_hd__fill_1_24 r0 *1 0,0
Xsky130_fd_sc_hd__fill_1_24 VSS VDD VDD sky130_fd_sc_hd__fill_1
* cell instance sky130_fd_sc_hd__fill_1_25 r0 *1 0,0
Xsky130_fd_sc_hd__fill_1_25 VSS VDD VDD sky130_fd_sc_hd__fill_1
* cell instance sky130_fd_sc_hd__fill_1_26 r0 *1 0,0
Xsky130_fd_sc_hd__fill_1_26 VSS VDD VDD sky130_fd_sc_hd__fill_1
* cell instance sky130_fd_sc_hd__fill_1_27 r0 *1 0,0
Xsky130_fd_sc_hd__fill_1_27 VSS VDD VDD sky130_fd_sc_hd__fill_1
* cell instance sky130_fd_sc_hd__fill_1_28 r0 *1 0,0
Xsky130_fd_sc_hd__fill_1_28 VSS VDD VDD sky130_fd_sc_hd__fill_1
* cell instance sky130_fd_sc_hd__fill_1_29 r0 *1 0,0
Xsky130_fd_sc_hd__fill_1_29 VSS VDD VDD sky130_fd_sc_hd__fill_1
* cell instance sky130_fd_sc_hd__fill_1_30 r0 *1 0,0
Xsky130_fd_sc_hd__fill_1_30 VSS VDD VDD sky130_fd_sc_hd__fill_1
* cell instance sky130_fd_sc_hd__fill_1_31 r0 *1 0,0
Xsky130_fd_sc_hd__fill_1_31 VSS VDD VDD sky130_fd_sc_hd__fill_1
* cell instance sky130_fd_sc_hd__fill_1_32 r0 *1 0,0
Xsky130_fd_sc_hd__fill_1_32 VSS VDD VDD sky130_fd_sc_hd__fill_1
* cell instance sky130_fd_sc_hd__fill_1_33 r0 *1 0,0
Xsky130_fd_sc_hd__fill_1_33 VSS VDD VDD sky130_fd_sc_hd__fill_1
* cell instance sky130_fd_sc_hd__fill_1_34 r0 *1 0,0
Xsky130_fd_sc_hd__fill_1_34 VSS VDD VDD sky130_fd_sc_hd__fill_1
* cell instance sky130_fd_sc_hd__fill_1_35 r0 *1 0,0
Xsky130_fd_sc_hd__fill_1_35 VSS VDD VDD sky130_fd_sc_hd__fill_1
* cell instance sky130_fd_sc_hd__fill_1_36 r0 *1 0,0
Xsky130_fd_sc_hd__fill_1_36 VSS VDD VDD sky130_fd_sc_hd__fill_1
* cell instance sky130_fd_sc_hd__fill_1_37 r0 *1 0,0
Xsky130_fd_sc_hd__fill_1_37 VSS VDD VDD sky130_fd_sc_hd__fill_1
* cell instance sky130_fd_sc_hd__fill_1_38 r0 *1 0,0
Xsky130_fd_sc_hd__fill_1_38 VSS VDD VDD sky130_fd_sc_hd__fill_1
* cell instance sky130_fd_sc_hd__fill_1_39 r0 *1 0,0
Xsky130_fd_sc_hd__fill_1_39 VSS VDD VDD sky130_fd_sc_hd__fill_1
* cell instance sky130_fd_sc_hd__fill_1_40 r0 *1 0,0
Xsky130_fd_sc_hd__fill_1_40 VSS VDD VDD sky130_fd_sc_hd__fill_1
* cell instance sky130_fd_sc_hd__fill_1_41 r0 *1 0,0
Xsky130_fd_sc_hd__fill_1_41 VSS VDD VDD sky130_fd_sc_hd__fill_1
* cell instance sky130_fd_sc_hd__fill_1_42 r0 *1 0,0
Xsky130_fd_sc_hd__fill_1_42 VSS VDD VDD sky130_fd_sc_hd__fill_1
* cell instance sky130_fd_sc_hd__fill_1_43 r0 *1 0,0
Xsky130_fd_sc_hd__fill_1_43 VSS VDD VDD sky130_fd_sc_hd__fill_1
* cell instance sky130_fd_sc_hd__fill_1_44 r0 *1 0,0
Xsky130_fd_sc_hd__fill_1_44 VSS VDD VDD sky130_fd_sc_hd__fill_1
* cell instance sky130_fd_sc_hd__fill_1_45 r0 *1 0,0
Xsky130_fd_sc_hd__fill_1_45 VSS VDD VDD sky130_fd_sc_hd__fill_1
* cell instance sky130_fd_sc_hd__fill_1_46 r0 *1 0,0
Xsky130_fd_sc_hd__fill_1_46 VSS VDD VDD sky130_fd_sc_hd__fill_1
* cell instance sky130_fd_sc_hd__fill_1_47 r0 *1 0,0
Xsky130_fd_sc_hd__fill_1_47 VSS VDD VDD sky130_fd_sc_hd__fill_1
* cell instance sky130_fd_sc_hd__fill_1_48 r0 *1 0,0
Xsky130_fd_sc_hd__fill_1_48 VSS VDD VDD sky130_fd_sc_hd__fill_1
* cell instance sky130_fd_sc_hd__fill_1_49 r0 *1 0,0
Xsky130_fd_sc_hd__fill_1_49 VSS VDD VDD sky130_fd_sc_hd__fill_1
* cell instance sky130_fd_sc_hd__fill_1_50 r0 *1 0,0
Xsky130_fd_sc_hd__fill_1_50 VSS VDD VDD sky130_fd_sc_hd__fill_1
* cell instance sky130_fd_sc_hd__fill_1_51 r0 *1 0,0
Xsky130_fd_sc_hd__fill_1_51 VSS VDD VDD sky130_fd_sc_hd__fill_1
* cell instance sky130_fd_sc_hd__fill_1_52 r0 *1 0,0
Xsky130_fd_sc_hd__fill_1_52 VSS VDD VDD sky130_fd_sc_hd__fill_1
* cell instance sky130_fd_sc_hd__fill_1_53 r0 *1 0,0
Xsky130_fd_sc_hd__fill_1_53 VSS VDD VDD sky130_fd_sc_hd__fill_1
* cell instance sky130_fd_sc_hd__fill_1_54 r0 *1 0,0
Xsky130_fd_sc_hd__fill_1_54 VSS VDD VDD sky130_fd_sc_hd__fill_1
* cell instance sky130_fd_sc_hd__fill_1_55 r0 *1 0,0
Xsky130_fd_sc_hd__fill_1_55 VSS VDD VDD sky130_fd_sc_hd__fill_1
* cell instance sky130_fd_sc_hd__fill_1_56 r0 *1 0,0
Xsky130_fd_sc_hd__fill_1_56 VSS VDD VDD sky130_fd_sc_hd__fill_1
* cell instance sky130_fd_sc_hd__fill_1_57 r0 *1 0,0
Xsky130_fd_sc_hd__fill_1_57 VSS VDD VDD sky130_fd_sc_hd__fill_1
* cell instance sky130_fd_sc_hd__fill_1_58 r0 *1 0,0
Xsky130_fd_sc_hd__fill_1_58 VSS VDD VDD sky130_fd_sc_hd__fill_1
* cell instance sky130_fd_sc_hd__fill_1_59 r0 *1 0,0
Xsky130_fd_sc_hd__fill_1_59 VSS VDD VDD sky130_fd_sc_hd__fill_1
* cell instance sky130_fd_sc_hd__fill_1_60 r0 *1 0,0
Xsky130_fd_sc_hd__fill_1_60 VSS VDD VDD sky130_fd_sc_hd__fill_1
* cell instance sky130_fd_sc_hd__fill_1_61 r0 *1 0,0
Xsky130_fd_sc_hd__fill_1_61 VSS VDD VDD sky130_fd_sc_hd__fill_1
* cell instance sky130_fd_sc_hd__fill_1_62 r0 *1 0,0
Xsky130_fd_sc_hd__fill_1_62 VSS VDD VDD sky130_fd_sc_hd__fill_1
* cell instance sky130_fd_sc_hd__fill_1_63 r0 *1 0,0
Xsky130_fd_sc_hd__fill_1_63 VSS VDD VDD sky130_fd_sc_hd__fill_1
* cell instance sky130_fd_sc_hd__fill_1_64 r0 *1 0,0
Xsky130_fd_sc_hd__fill_1_64 VSS VDD VDD sky130_fd_sc_hd__fill_1
* cell instance sky130_fd_sc_hd__fill_1_65 r0 *1 0,0
Xsky130_fd_sc_hd__fill_1_65 VSS VDD VDD sky130_fd_sc_hd__fill_1
* cell instance sky130_fd_sc_hd__fill_1_66 r0 *1 0,0
Xsky130_fd_sc_hd__fill_1_66 VSS VDD VDD sky130_fd_sc_hd__fill_1
* cell instance sky130_fd_sc_hd__fill_1_67 r0 *1 0,0
Xsky130_fd_sc_hd__fill_1_67 VSS VDD VDD sky130_fd_sc_hd__fill_1
* cell instance sky130_fd_sc_hd__fill_1_68 r0 *1 0,0
Xsky130_fd_sc_hd__fill_1_68 VSS VDD VDD sky130_fd_sc_hd__fill_1
* cell instance sky130_fd_sc_hd__fill_1_69 r0 *1 0,0
Xsky130_fd_sc_hd__fill_1_69 VSS VDD VDD sky130_fd_sc_hd__fill_1
* cell instance sky130_fd_sc_hd__fill_1_70 r0 *1 0,0
Xsky130_fd_sc_hd__fill_1_70 VSS VDD VDD sky130_fd_sc_hd__fill_1
* cell instance sky130_fd_sc_hd__fill_1_71 r0 *1 0,0
Xsky130_fd_sc_hd__fill_1_71 VSS VDD VDD sky130_fd_sc_hd__fill_1
* cell instance sky130_fd_sc_hd__fill_1_72 r0 *1 0,0
Xsky130_fd_sc_hd__fill_1_72 VSS VDD VDD sky130_fd_sc_hd__fill_1
* cell instance sky130_fd_sc_hd__fill_1_73 r0 *1 0,0
Xsky130_fd_sc_hd__fill_1_73 VSS VDD VDD sky130_fd_sc_hd__fill_1
* cell instance sky130_fd_sc_hd__fill_1_74 r0 *1 0,0
Xsky130_fd_sc_hd__fill_1_74 VSS VDD VDD sky130_fd_sc_hd__fill_1
* cell instance sky130_fd_sc_hd__fill_1_75 r0 *1 0,0
Xsky130_fd_sc_hd__fill_1_75 VSS VDD VDD sky130_fd_sc_hd__fill_1
* cell instance sky130_fd_sc_hd__fill_1_76 r0 *1 0,0
Xsky130_fd_sc_hd__fill_1_76 VSS VDD VDD sky130_fd_sc_hd__fill_1
* cell instance sky130_fd_sc_hd__fill_1_77 r0 *1 0,0
Xsky130_fd_sc_hd__fill_1_77 VSS VDD VDD sky130_fd_sc_hd__fill_1
* cell instance sky130_fd_sc_hd__fill_1_78 r0 *1 0,0
Xsky130_fd_sc_hd__fill_1_78 VSS VDD VDD sky130_fd_sc_hd__fill_1
* cell instance sky130_fd_sc_hd__fill_1_79 r0 *1 0,0
Xsky130_fd_sc_hd__fill_1_79 VSS VDD VDD sky130_fd_sc_hd__fill_1
* cell instance sky130_fd_sc_hd__fill_1_80 r0 *1 0,0
Xsky130_fd_sc_hd__fill_1_80 VSS VDD VDD sky130_fd_sc_hd__fill_1
* cell instance sky130_fd_sc_hd__fill_1_81 r0 *1 0,0
Xsky130_fd_sc_hd__fill_1_81 VSS VDD VDD sky130_fd_sc_hd__fill_1
* cell instance sky130_fd_sc_hd__fill_1_82 r0 *1 0,0
Xsky130_fd_sc_hd__fill_1_82 VSS VDD VDD sky130_fd_sc_hd__fill_1
* cell instance sky130_fd_sc_hd__fill_1_83 r0 *1 0,0
Xsky130_fd_sc_hd__fill_1_83 VSS VDD VDD sky130_fd_sc_hd__fill_1
* cell instance sky130_fd_sc_hd__fill_1_84 r0 *1 0,0
Xsky130_fd_sc_hd__fill_1_84 VSS VDD VDD sky130_fd_sc_hd__fill_1
* cell instance sky130_fd_sc_hd__fill_1_85 r0 *1 0,0
Xsky130_fd_sc_hd__fill_1_85 VSS VDD VDD sky130_fd_sc_hd__fill_1
* cell instance sky130_fd_sc_hd__fill_1_86 r0 *1 0,0
Xsky130_fd_sc_hd__fill_1_86 VSS VDD VDD sky130_fd_sc_hd__fill_1
* cell instance sky130_fd_sc_hd__fill_1_87 r0 *1 0,0
Xsky130_fd_sc_hd__fill_1_87 VSS VDD VDD sky130_fd_sc_hd__fill_1
* cell instance sky130_fd_sc_hd__fill_1_88 r0 *1 0,0
Xsky130_fd_sc_hd__fill_1_88 VSS VDD VDD sky130_fd_sc_hd__fill_1
* cell instance sky130_fd_sc_hd__fill_1_89 r0 *1 0,0
Xsky130_fd_sc_hd__fill_1_89 VSS VDD VDD sky130_fd_sc_hd__fill_1
* cell instance sky130_fd_sc_hd__fill_1_90 r0 *1 0,0
Xsky130_fd_sc_hd__fill_1_90 VSS VDD VDD sky130_fd_sc_hd__fill_1
* cell instance sky130_fd_sc_hd__fill_1_91 r0 *1 0,0
Xsky130_fd_sc_hd__fill_1_91 VSS VDD VDD sky130_fd_sc_hd__fill_1
* cell instance sky130_fd_sc_hd__fill_1_92 r0 *1 0,0
Xsky130_fd_sc_hd__fill_1_92 VSS VDD VDD sky130_fd_sc_hd__fill_1
* cell instance sky130_fd_sc_hd__fill_1_93 r0 *1 0,0
Xsky130_fd_sc_hd__fill_1_93 VSS VDD VDD sky130_fd_sc_hd__fill_1
* cell instance sky130_fd_sc_hd__fill_1_94 r0 *1 0,0
Xsky130_fd_sc_hd__fill_1_94 VSS VDD VDD sky130_fd_sc_hd__fill_1
* cell instance sky130_fd_sc_hd__fill_1_95 r0 *1 0,0
Xsky130_fd_sc_hd__fill_1_95 VSS VDD VDD sky130_fd_sc_hd__fill_1
* cell instance sky130_fd_sc_hd__fill_1_96 r0 *1 0,0
Xsky130_fd_sc_hd__fill_1_96 VSS VDD VDD sky130_fd_sc_hd__fill_1
* cell instance sky130_fd_sc_hd__fill_1_97 r0 *1 0,0
Xsky130_fd_sc_hd__fill_1_97 VSS VDD VDD sky130_fd_sc_hd__fill_1
* cell instance sky130_fd_sc_hd__fill_1_98 r0 *1 0,0
Xsky130_fd_sc_hd__fill_1_98 VSS VDD VDD sky130_fd_sc_hd__fill_1
* cell instance sky130_fd_sc_hd__fill_1_99 r0 *1 0,0
Xsky130_fd_sc_hd__fill_1_99 VSS VDD VDD sky130_fd_sc_hd__fill_1
* cell instance sky130_fd_sc_hd__fill_1_100 r0 *1 0,0
Xsky130_fd_sc_hd__fill_1_100 VSS VDD VDD sky130_fd_sc_hd__fill_1
* cell instance sky130_fd_sc_hd__fill_1_101 r0 *1 0,0
Xsky130_fd_sc_hd__fill_1_101 VSS VDD VDD sky130_fd_sc_hd__fill_1
* cell instance sky130_fd_sc_hd__fill_1_102 r0 *1 0,0
Xsky130_fd_sc_hd__fill_1_102 VSS VDD VDD sky130_fd_sc_hd__fill_1
* cell instance sky130_fd_sc_hd__fill_1_103 r0 *1 0,0
Xsky130_fd_sc_hd__fill_1_103 VSS VDD VDD sky130_fd_sc_hd__fill_1
* cell instance sky130_fd_sc_hd__fill_1_104 r0 *1 0,0
Xsky130_fd_sc_hd__fill_1_104 VSS VDD VDD sky130_fd_sc_hd__fill_1
* cell instance sky130_fd_sc_hd__fill_1_105 r0 *1 0,0
Xsky130_fd_sc_hd__fill_1_105 VSS VDD VDD sky130_fd_sc_hd__fill_1
* cell instance sky130_fd_sc_hd__fill_1_106 r0 *1 0,0
Xsky130_fd_sc_hd__fill_1_106 VSS VDD VDD sky130_fd_sc_hd__fill_1
* cell instance sky130_fd_sc_hd__fill_1_107 r0 *1 0,0
Xsky130_fd_sc_hd__fill_1_107 VSS VDD VDD sky130_fd_sc_hd__fill_1
* cell instance sky130_fd_sc_hd__fill_1_108 r0 *1 0,0
Xsky130_fd_sc_hd__fill_1_108 VSS VDD VDD sky130_fd_sc_hd__fill_1
* cell instance sky130_fd_sc_hd__fill_1_109 r0 *1 0,0
Xsky130_fd_sc_hd__fill_1_109 VSS VDD VDD sky130_fd_sc_hd__fill_1
* cell instance sky130_fd_sc_hd__fill_1_110 r0 *1 0,0
Xsky130_fd_sc_hd__fill_1_110 VSS VDD VDD sky130_fd_sc_hd__fill_1
* cell instance sky130_fd_sc_hd__fill_1_111 r0 *1 0,0
Xsky130_fd_sc_hd__fill_1_111 VSS VDD VDD sky130_fd_sc_hd__fill_1
* cell instance sky130_fd_sc_hd__fill_1_112 r0 *1 0,0
Xsky130_fd_sc_hd__fill_1_112 VSS VDD VDD sky130_fd_sc_hd__fill_1
* cell instance sky130_fd_sc_hd__fill_1_113 r0 *1 0,0
Xsky130_fd_sc_hd__fill_1_113 VSS VDD VDD sky130_fd_sc_hd__fill_1
* cell instance sky130_fd_sc_hd__fill_1_114 r0 *1 0,0
Xsky130_fd_sc_hd__fill_1_114 VSS VDD VDD sky130_fd_sc_hd__fill_1
* cell instance sky130_fd_sc_hd__fill_1_115 r0 *1 0,0
Xsky130_fd_sc_hd__fill_1_115 VSS VDD VDD sky130_fd_sc_hd__fill_1
* cell instance sky130_fd_sc_hd__fill_1_116 r0 *1 0,0
Xsky130_fd_sc_hd__fill_1_116 VSS VDD VDD sky130_fd_sc_hd__fill_1
* cell instance sky130_fd_sc_hd__fill_1_117 r0 *1 0,0
Xsky130_fd_sc_hd__fill_1_117 VSS VDD VDD sky130_fd_sc_hd__fill_1
* cell instance sky130_fd_sc_hd__fill_1_118 r0 *1 0,0
Xsky130_fd_sc_hd__fill_1_118 VSS VDD VDD sky130_fd_sc_hd__fill_1
* cell instance sky130_fd_sc_hd__fill_1_119 r0 *1 0,0
Xsky130_fd_sc_hd__fill_1_119 VSS VDD VDD sky130_fd_sc_hd__fill_1
* cell instance sky130_fd_sc_hd__fill_1_120 r0 *1 0,0
Xsky130_fd_sc_hd__fill_1_120 VSS VDD VDD sky130_fd_sc_hd__fill_1
* cell instance sky130_fd_sc_hd__fill_1_121 r0 *1 0,0
Xsky130_fd_sc_hd__fill_1_121 VSS VDD VDD sky130_fd_sc_hd__fill_1
* cell instance sky130_fd_sc_hd__fill_1_122 r0 *1 0,0
Xsky130_fd_sc_hd__fill_1_122 VSS VDD VDD sky130_fd_sc_hd__fill_1
* cell instance sky130_fd_sc_hd__fill_1_123 r0 *1 0,0
Xsky130_fd_sc_hd__fill_1_123 VSS VDD VDD sky130_fd_sc_hd__fill_1
* cell instance sky130_fd_sc_hd__fill_1_124 r0 *1 0,0
Xsky130_fd_sc_hd__fill_1_124 VSS VDD VDD sky130_fd_sc_hd__fill_1
* cell instance sky130_fd_sc_hd__fill_1_125 r0 *1 0,0
Xsky130_fd_sc_hd__fill_1_125 VSS VDD VDD sky130_fd_sc_hd__fill_1
* cell instance sky130_fd_sc_hd__fill_1_126 r0 *1 0,0
Xsky130_fd_sc_hd__fill_1_126 VSS VDD VDD sky130_fd_sc_hd__fill_1
* cell instance sky130_fd_sc_hd__fill_1_127 r0 *1 0,0
Xsky130_fd_sc_hd__fill_1_127 VSS VDD VDD sky130_fd_sc_hd__fill_1
* cell instance sky130_fd_sc_hd__fill_1_128 r0 *1 0,0
Xsky130_fd_sc_hd__fill_1_128 VSS VDD VDD sky130_fd_sc_hd__fill_1
* cell instance sky130_fd_sc_hd__fill_1_129 r0 *1 0,0
Xsky130_fd_sc_hd__fill_1_129 VSS VDD VDD sky130_fd_sc_hd__fill_1
* cell instance sky130_fd_sc_hd__fill_1_130 r0 *1 0,0
Xsky130_fd_sc_hd__fill_1_130 VSS VDD VDD sky130_fd_sc_hd__fill_1
* cell instance sky130_fd_sc_hd__fill_1_131 r0 *1 0,0
Xsky130_fd_sc_hd__fill_1_131 VSS VDD VDD sky130_fd_sc_hd__fill_1
* cell instance sky130_fd_sc_hd__fill_1_132 r0 *1 0,0
Xsky130_fd_sc_hd__fill_1_132 VSS VDD VDD sky130_fd_sc_hd__fill_1
* cell instance sky130_fd_sc_hd__fill_1_133 r0 *1 0,0
Xsky130_fd_sc_hd__fill_1_133 VSS VDD VDD sky130_fd_sc_hd__fill_1
* cell instance sky130_fd_sc_hd__fill_1_134 r0 *1 0,0
Xsky130_fd_sc_hd__fill_1_134 VSS VDD VDD sky130_fd_sc_hd__fill_1
* cell instance sky130_fd_sc_hd__fill_1_135 r0 *1 0,0
Xsky130_fd_sc_hd__fill_1_135 VSS VDD VDD sky130_fd_sc_hd__fill_1
* cell instance sky130_fd_sc_hd__fill_1_136 r0 *1 0,0
Xsky130_fd_sc_hd__fill_1_136 VSS VDD VDD sky130_fd_sc_hd__fill_1
* cell instance sky130_fd_sc_hd__fill_1_137 r0 *1 0,0
Xsky130_fd_sc_hd__fill_1_137 VSS VDD VDD sky130_fd_sc_hd__fill_1
* cell instance sky130_fd_sc_hd__fill_1_138 r0 *1 0,0
Xsky130_fd_sc_hd__fill_1_138 VSS VDD VDD sky130_fd_sc_hd__fill_1
* cell instance sky130_fd_sc_hd__fill_1_139 r0 *1 0,0
Xsky130_fd_sc_hd__fill_1_139 VSS VDD VDD sky130_fd_sc_hd__fill_1
* cell instance sky130_fd_sc_hd__fill_1_140 r0 *1 0,0
Xsky130_fd_sc_hd__fill_1_140 VSS VDD VDD sky130_fd_sc_hd__fill_1
* cell instance sky130_fd_sc_hd__fill_1_141 r0 *1 0,0
Xsky130_fd_sc_hd__fill_1_141 VSS VDD VDD sky130_fd_sc_hd__fill_1
* cell instance sky130_fd_sc_hd__fill_1_142 r0 *1 0,0
Xsky130_fd_sc_hd__fill_1_142 VSS VDD VDD sky130_fd_sc_hd__fill_1
* cell instance sky130_fd_sc_hd__fill_1_143 r0 *1 0,0
Xsky130_fd_sc_hd__fill_1_143 VSS VDD VDD sky130_fd_sc_hd__fill_1
* cell instance sky130_fd_sc_hd__fill_1_144 r0 *1 0,0
Xsky130_fd_sc_hd__fill_1_144 VSS VDD VDD sky130_fd_sc_hd__fill_1
* cell instance sky130_fd_sc_hd__fill_1_145 r0 *1 0,0
Xsky130_fd_sc_hd__fill_1_145 VSS VDD VDD sky130_fd_sc_hd__fill_1
* cell instance sky130_fd_sc_hd__fill_1_146 r0 *1 0,0
Xsky130_fd_sc_hd__fill_1_146 VSS VDD VDD sky130_fd_sc_hd__fill_1
* cell instance sky130_fd_sc_hd__fill_1_147 r0 *1 0,0
Xsky130_fd_sc_hd__fill_1_147 VSS VDD VDD sky130_fd_sc_hd__fill_1
* cell instance sky130_fd_sc_hd__fill_1_148 r0 *1 0,0
Xsky130_fd_sc_hd__fill_1_148 VSS VDD VDD sky130_fd_sc_hd__fill_1
* cell instance sky130_fd_sc_hd__fill_1_149 r0 *1 0,0
Xsky130_fd_sc_hd__fill_1_149 VSS VDD VDD sky130_fd_sc_hd__fill_1
* cell instance sky130_fd_sc_hd__fill_1_150 r0 *1 0,0
Xsky130_fd_sc_hd__fill_1_150 VSS VDD VDD sky130_fd_sc_hd__fill_1
* cell instance sky130_fd_sc_hd__fill_1_151 r0 *1 0,0
Xsky130_fd_sc_hd__fill_1_151 VSS VDD VDD sky130_fd_sc_hd__fill_1
* cell instance sky130_fd_sc_hd__fill_1_152 r0 *1 0,0
Xsky130_fd_sc_hd__fill_1_152 VSS VDD VDD sky130_fd_sc_hd__fill_1
* cell instance sky130_fd_sc_hd__fill_1_153 r0 *1 0,0
Xsky130_fd_sc_hd__fill_1_153 VSS VDD VDD sky130_fd_sc_hd__fill_1
* cell instance sky130_fd_sc_hd__fill_1_154 r0 *1 0,0
Xsky130_fd_sc_hd__fill_1_154 VSS VDD VDD sky130_fd_sc_hd__fill_1
* cell instance sky130_fd_sc_hd__fill_1_155 r0 *1 0,0
Xsky130_fd_sc_hd__fill_1_155 VSS VDD VDD sky130_fd_sc_hd__fill_1
* cell instance sky130_fd_sc_hd__fill_1_156 r0 *1 0,0
Xsky130_fd_sc_hd__fill_1_156 VSS VDD VDD sky130_fd_sc_hd__fill_1
* cell instance sky130_fd_sc_hd__fill_1_157 r0 *1 0,0
Xsky130_fd_sc_hd__fill_1_157 VSS VDD VDD sky130_fd_sc_hd__fill_1
* cell instance sky130_fd_sc_hd__fill_1_158 r0 *1 0,0
Xsky130_fd_sc_hd__fill_1_158 VSS VDD VDD sky130_fd_sc_hd__fill_1
* cell instance sky130_fd_sc_hd__fill_1_159 r0 *1 0,0
Xsky130_fd_sc_hd__fill_1_159 VSS VDD VDD sky130_fd_sc_hd__fill_1
* cell instance sky130_fd_sc_hd__fill_1_160 r0 *1 0,0
Xsky130_fd_sc_hd__fill_1_160 VSS VDD VDD sky130_fd_sc_hd__fill_1
* cell instance sky130_fd_sc_hd__fill_1_161 r0 *1 0,0
Xsky130_fd_sc_hd__fill_1_161 VSS VDD VDD sky130_fd_sc_hd__fill_1
* cell instance sky130_fd_sc_hd__fill_1_162 r0 *1 0,0
Xsky130_fd_sc_hd__fill_1_162 VSS VDD VDD sky130_fd_sc_hd__fill_1
* cell instance sky130_fd_sc_hd__fill_1_163 r0 *1 0,0
Xsky130_fd_sc_hd__fill_1_163 VSS VDD VDD sky130_fd_sc_hd__fill_1
* cell instance sky130_fd_sc_hd__fill_1_164 r0 *1 0,0
Xsky130_fd_sc_hd__fill_1_164 VSS VDD VDD sky130_fd_sc_hd__fill_1
* cell instance sky130_fd_sc_hd__fill_1_165 r0 *1 0,0
Xsky130_fd_sc_hd__fill_1_165 VSS VDD VDD sky130_fd_sc_hd__fill_1
* cell instance sky130_fd_sc_hd__fill_1_166 r0 *1 0,0
Xsky130_fd_sc_hd__fill_1_166 VSS VDD VDD sky130_fd_sc_hd__fill_1
* cell instance sky130_fd_sc_hd__fill_1_167 r0 *1 0,0
Xsky130_fd_sc_hd__fill_1_167 VSS VDD VDD sky130_fd_sc_hd__fill_1
* cell instance sky130_fd_sc_hd__fill_1_168 r0 *1 0,0
Xsky130_fd_sc_hd__fill_1_168 VSS VDD VDD sky130_fd_sc_hd__fill_1
* cell instance sky130_fd_sc_hd__fill_1_169 r0 *1 0,0
Xsky130_fd_sc_hd__fill_1_169 VSS VDD VDD sky130_fd_sc_hd__fill_1
* cell instance sky130_fd_sc_hd__fill_1_170 r0 *1 0,0
Xsky130_fd_sc_hd__fill_1_170 VSS VDD VDD sky130_fd_sc_hd__fill_1
* cell instance sky130_fd_sc_hd__fill_1_171 r0 *1 0,0
Xsky130_fd_sc_hd__fill_1_171 VSS VDD VDD sky130_fd_sc_hd__fill_1
* cell instance sky130_fd_sc_hd__fill_1_172 r0 *1 0,0
Xsky130_fd_sc_hd__fill_1_172 VSS VDD VDD sky130_fd_sc_hd__fill_1
* cell instance sky130_fd_sc_hd__fill_1_173 r0 *1 0,0
Xsky130_fd_sc_hd__fill_1_173 VSS VDD VDD sky130_fd_sc_hd__fill_1
* cell instance sky130_fd_sc_hd__fill_1_174 r0 *1 0,0
Xsky130_fd_sc_hd__fill_1_174 VSS VDD VDD sky130_fd_sc_hd__fill_1
* cell instance sky130_fd_sc_hd__fill_1_175 r0 *1 0,0
Xsky130_fd_sc_hd__fill_1_175 VSS VDD VDD sky130_fd_sc_hd__fill_1
* cell instance sky130_fd_sc_hd__fill_1_176 r0 *1 0,0
Xsky130_fd_sc_hd__fill_1_176 VSS VDD VDD sky130_fd_sc_hd__fill_1
* cell instance sky130_fd_sc_hd__fill_1_177 r0 *1 0,0
Xsky130_fd_sc_hd__fill_1_177 VSS VDD VDD sky130_fd_sc_hd__fill_1
* cell instance sky130_fd_sc_hd__fill_1_178 r0 *1 0,0
Xsky130_fd_sc_hd__fill_1_178 VSS VDD VDD sky130_fd_sc_hd__fill_1
* cell instance sky130_fd_sc_hd__fill_1_179 r0 *1 0,0
Xsky130_fd_sc_hd__fill_1_179 VSS VDD VDD sky130_fd_sc_hd__fill_1
* cell instance sky130_fd_sc_hd__fill_1_180 r0 *1 0,0
Xsky130_fd_sc_hd__fill_1_180 VSS VDD VDD sky130_fd_sc_hd__fill_1
* cell instance sky130_fd_sc_hd__fill_1_181 r0 *1 0,0
Xsky130_fd_sc_hd__fill_1_181 VSS VDD VDD sky130_fd_sc_hd__fill_1
* cell instance sky130_fd_sc_hd__fill_1_182 r0 *1 0,0
Xsky130_fd_sc_hd__fill_1_182 VSS VDD VDD sky130_fd_sc_hd__fill_1
* cell instance sky130_fd_sc_hd__fill_1_183 r0 *1 0,0
Xsky130_fd_sc_hd__fill_1_183 VSS VDD VDD sky130_fd_sc_hd__fill_1
* cell instance sky130_fd_sc_hd__fill_1_184 r0 *1 0,0
Xsky130_fd_sc_hd__fill_1_184 VSS VDD VDD sky130_fd_sc_hd__fill_1
* cell instance sky130_fd_sc_hd__fill_1_185 r0 *1 0,0
Xsky130_fd_sc_hd__fill_1_185 VSS VDD VDD sky130_fd_sc_hd__fill_1
* cell instance sky130_fd_sc_hd__fill_1_186 r0 *1 0,0
Xsky130_fd_sc_hd__fill_1_186 VSS VDD VDD sky130_fd_sc_hd__fill_1
* cell instance sky130_fd_sc_hd__fill_1_187 r0 *1 0,0
Xsky130_fd_sc_hd__fill_1_187 VSS VDD VDD sky130_fd_sc_hd__fill_1
* cell instance sky130_fd_sc_hd__fill_1_188 r0 *1 0,0
Xsky130_fd_sc_hd__fill_1_188 VSS VDD VDD sky130_fd_sc_hd__fill_1
* cell instance sky130_fd_sc_hd__fill_1_189 r0 *1 0,0
Xsky130_fd_sc_hd__fill_1_189 VSS VDD VDD sky130_fd_sc_hd__fill_1
* cell instance sky130_fd_sc_hd__fill_1_190 r0 *1 0,0
Xsky130_fd_sc_hd__fill_1_190 VSS VDD VDD sky130_fd_sc_hd__fill_1
* cell instance sky130_fd_sc_hd__fill_1_191 r0 *1 0,0
Xsky130_fd_sc_hd__fill_1_191 VSS VDD VDD sky130_fd_sc_hd__fill_1
* cell instance sky130_fd_sc_hd__fill_1_192 r0 *1 0,0
Xsky130_fd_sc_hd__fill_1_192 VSS VDD VDD sky130_fd_sc_hd__fill_1
* cell instance sky130_fd_sc_hd__fill_1_193 r0 *1 0,0
Xsky130_fd_sc_hd__fill_1_193 VSS VDD VDD sky130_fd_sc_hd__fill_1
* cell instance sky130_fd_sc_hd__fill_1_194 r0 *1 0,0
Xsky130_fd_sc_hd__fill_1_194 VSS VDD VDD sky130_fd_sc_hd__fill_1
* cell instance sky130_fd_sc_hd__fill_1_195 r0 *1 0,0
Xsky130_fd_sc_hd__fill_1_195 VSS VDD VDD sky130_fd_sc_hd__fill_1
* cell instance sky130_fd_sc_hd__fill_1_196 r0 *1 0,0
Xsky130_fd_sc_hd__fill_1_196 VSS VDD VDD sky130_fd_sc_hd__fill_1
* cell instance sky130_fd_sc_hd__fill_1_197 r0 *1 0,0
Xsky130_fd_sc_hd__fill_1_197 VSS VDD VDD sky130_fd_sc_hd__fill_1
* cell instance sky130_fd_sc_hd__fill_1_198 r0 *1 0,0
Xsky130_fd_sc_hd__fill_1_198 VSS VDD VDD sky130_fd_sc_hd__fill_1
* cell instance sky130_fd_sc_hd__fill_1_199 r0 *1 0,0
Xsky130_fd_sc_hd__fill_1_199 VSS VDD VDD sky130_fd_sc_hd__fill_1
* cell instance sky130_fd_sc_hd__fill_1_200 r0 *1 0,0
Xsky130_fd_sc_hd__fill_1_200 VSS VDD VDD sky130_fd_sc_hd__fill_1
* cell instance sky130_fd_sc_hd__fill_1_201 r0 *1 0,0
Xsky130_fd_sc_hd__fill_1_201 VSS VDD VDD sky130_fd_sc_hd__fill_1
* cell instance sky130_fd_sc_hd__fill_1_202 r0 *1 0,0
Xsky130_fd_sc_hd__fill_1_202 VSS VDD VDD sky130_fd_sc_hd__fill_1
* cell instance sky130_fd_sc_hd__fill_1_203 r0 *1 0,0
Xsky130_fd_sc_hd__fill_1_203 VSS VDD VDD sky130_fd_sc_hd__fill_1
* cell instance sky130_fd_sc_hd__fill_1_204 r0 *1 0,0
Xsky130_fd_sc_hd__fill_1_204 VSS VDD VDD sky130_fd_sc_hd__fill_1
* cell instance sky130_fd_sc_hd__fill_1_205 r0 *1 0,0
Xsky130_fd_sc_hd__fill_1_205 VSS VDD VDD sky130_fd_sc_hd__fill_1
* cell instance sky130_fd_sc_hd__fill_1_206 r0 *1 0,0
Xsky130_fd_sc_hd__fill_1_206 VSS VDD VDD sky130_fd_sc_hd__fill_1
* cell instance sky130_fd_sc_hd__fill_1_207 r0 *1 0,0
Xsky130_fd_sc_hd__fill_1_207 VSS VDD VDD sky130_fd_sc_hd__fill_1
* cell instance sky130_fd_sc_hd__fill_1_208 r0 *1 0,0
Xsky130_fd_sc_hd__fill_1_208 VSS VDD VDD sky130_fd_sc_hd__fill_1
* cell instance sky130_fd_sc_hd__fill_1_209 r0 *1 0,0
Xsky130_fd_sc_hd__fill_1_209 VSS VDD VDD sky130_fd_sc_hd__fill_1
* cell instance sky130_fd_sc_hd__fill_1_210 r0 *1 0,0
Xsky130_fd_sc_hd__fill_1_210 VSS VDD VDD sky130_fd_sc_hd__fill_1
* cell instance sky130_fd_sc_hd__fill_1_211 r0 *1 0,0
Xsky130_fd_sc_hd__fill_1_211 VSS VDD VDD sky130_fd_sc_hd__fill_1
* cell instance sky130_fd_sc_hd__fill_1_212 r0 *1 0,0
Xsky130_fd_sc_hd__fill_1_212 VSS VDD VDD sky130_fd_sc_hd__fill_1
* cell instance sky130_fd_sc_hd__fill_1_213 r0 *1 0,0
Xsky130_fd_sc_hd__fill_1_213 VSS VDD VDD sky130_fd_sc_hd__fill_1
* cell instance sky130_fd_sc_hd__fill_1_214 r0 *1 0,0
Xsky130_fd_sc_hd__fill_1_214 VSS VDD VDD sky130_fd_sc_hd__fill_1
* cell instance sky130_fd_sc_hd__fill_1_215 r0 *1 0,0
Xsky130_fd_sc_hd__fill_1_215 VSS VDD VDD sky130_fd_sc_hd__fill_1
* cell instance sky130_fd_sc_hd__fill_1_216 r0 *1 0,0
Xsky130_fd_sc_hd__fill_1_216 VSS VDD VDD sky130_fd_sc_hd__fill_1
* cell instance sky130_fd_sc_hd__fill_1_217 r0 *1 0,0
Xsky130_fd_sc_hd__fill_1_217 VSS VDD VDD sky130_fd_sc_hd__fill_1
* cell instance sky130_fd_sc_hd__fill_1_218 r0 *1 0,0
Xsky130_fd_sc_hd__fill_1_218 VSS VDD VDD sky130_fd_sc_hd__fill_1
* cell instance sky130_fd_sc_hd__fill_1_219 r0 *1 0,0
Xsky130_fd_sc_hd__fill_1_219 VSS VDD VDD sky130_fd_sc_hd__fill_1
* cell instance sky130_fd_sc_hd__fill_1_220 r0 *1 0,0
Xsky130_fd_sc_hd__fill_1_220 VSS VDD VDD sky130_fd_sc_hd__fill_1
* cell instance sky130_fd_sc_hd__fill_1_221 r0 *1 0,0
Xsky130_fd_sc_hd__fill_1_221 VSS VDD VDD sky130_fd_sc_hd__fill_1
* cell instance sky130_fd_sc_hd__fill_1_222 r0 *1 0,0
Xsky130_fd_sc_hd__fill_1_222 VSS VDD VDD sky130_fd_sc_hd__fill_1
* cell instance sky130_fd_sc_hd__fill_1_223 r0 *1 0,0
Xsky130_fd_sc_hd__fill_1_223 VSS VDD VDD sky130_fd_sc_hd__fill_1
* cell instance sky130_fd_sc_hd__fill_1_224 r0 *1 0,0
Xsky130_fd_sc_hd__fill_1_224 VSS VDD VDD sky130_fd_sc_hd__fill_1
* cell instance sky130_fd_sc_hd__fill_1_225 r0 *1 0,0
Xsky130_fd_sc_hd__fill_1_225 VSS VDD VDD sky130_fd_sc_hd__fill_1
* cell instance sky130_fd_sc_hd__fill_1_226 r0 *1 0,0
Xsky130_fd_sc_hd__fill_1_226 VSS VDD VDD sky130_fd_sc_hd__fill_1
* cell instance sky130_fd_sc_hd__fill_1_227 r0 *1 0,0
Xsky130_fd_sc_hd__fill_1_227 VSS VDD VDD sky130_fd_sc_hd__fill_1
* cell instance sky130_fd_sc_hd__fill_1_228 r0 *1 0,0
Xsky130_fd_sc_hd__fill_1_228 VSS VDD VDD sky130_fd_sc_hd__fill_1
* cell instance sky130_fd_sc_hd__fill_1_229 r0 *1 0,0
Xsky130_fd_sc_hd__fill_1_229 VSS VDD VDD sky130_fd_sc_hd__fill_1
* cell instance sky130_fd_sc_hd__fill_1_230 r0 *1 0,0
Xsky130_fd_sc_hd__fill_1_230 VSS VDD VDD sky130_fd_sc_hd__fill_1
* cell instance sky130_fd_sc_hd__fill_1_231 r0 *1 0,0
Xsky130_fd_sc_hd__fill_1_231 VSS VDD VDD sky130_fd_sc_hd__fill_1
* cell instance sky130_fd_sc_hd__fill_1_232 r0 *1 0,0
Xsky130_fd_sc_hd__fill_1_232 VSS VDD VDD sky130_fd_sc_hd__fill_1
* cell instance sky130_fd_sc_hd__fill_1_233 r0 *1 0,0
Xsky130_fd_sc_hd__fill_1_233 VSS VDD VDD sky130_fd_sc_hd__fill_1
* cell instance sky130_fd_sc_hd__fill_1_234 r0 *1 0,0
Xsky130_fd_sc_hd__fill_1_234 VSS VDD VDD sky130_fd_sc_hd__fill_1
* cell instance sky130_fd_sc_hd__fill_1_235 r0 *1 0,0
Xsky130_fd_sc_hd__fill_1_235 VSS VDD VDD sky130_fd_sc_hd__fill_1
* cell instance sky130_fd_sc_hd__fill_1_236 r0 *1 0,0
Xsky130_fd_sc_hd__fill_1_236 VSS VDD VDD sky130_fd_sc_hd__fill_1
* cell instance sky130_fd_sc_hd__fill_1_237 r0 *1 0,0
Xsky130_fd_sc_hd__fill_1_237 VSS VDD VDD sky130_fd_sc_hd__fill_1
* cell instance sky130_fd_sc_hd__fill_1_238 r0 *1 0,0
Xsky130_fd_sc_hd__fill_1_238 VSS VDD VDD sky130_fd_sc_hd__fill_1
* cell instance sky130_fd_sc_hd__fill_1_239 r0 *1 0,0
Xsky130_fd_sc_hd__fill_1_239 VSS VDD VDD sky130_fd_sc_hd__fill_1
* cell instance sky130_fd_sc_hd__fill_1_240 r0 *1 0,0
Xsky130_fd_sc_hd__fill_1_240 VSS VDD VDD sky130_fd_sc_hd__fill_1
* cell instance sky130_fd_sc_hd__fill_1_241 r0 *1 0,0
Xsky130_fd_sc_hd__fill_1_241 VSS VDD VDD sky130_fd_sc_hd__fill_1
* cell instance sky130_fd_sc_hd__fill_1_242 r0 *1 0,0
Xsky130_fd_sc_hd__fill_1_242 VSS VDD VDD sky130_fd_sc_hd__fill_1
* cell instance sky130_fd_sc_hd__fill_1_243 r0 *1 0,0
Xsky130_fd_sc_hd__fill_1_243 VSS VDD VDD sky130_fd_sc_hd__fill_1
* cell instance sky130_fd_sc_hd__fill_1_244 r0 *1 0,0
Xsky130_fd_sc_hd__fill_1_244 VSS VDD VDD sky130_fd_sc_hd__fill_1
* cell instance sky130_fd_sc_hd__fill_1_245 r0 *1 0,0
Xsky130_fd_sc_hd__fill_1_245 VSS VDD VDD sky130_fd_sc_hd__fill_1
* cell instance sky130_fd_sc_hd__fill_1_246 r0 *1 0,0
Xsky130_fd_sc_hd__fill_1_246 VSS VDD VDD sky130_fd_sc_hd__fill_1
* cell instance sky130_fd_sc_hd__fill_1_247 r0 *1 0,0
Xsky130_fd_sc_hd__fill_1_247 VSS VDD VDD sky130_fd_sc_hd__fill_1
* cell instance sky130_fd_sc_hd__fill_1_248 r0 *1 0,0
Xsky130_fd_sc_hd__fill_1_248 VSS VDD VDD sky130_fd_sc_hd__fill_1
* cell instance sky130_fd_sc_hd__fill_1_249 r0 *1 0,0
Xsky130_fd_sc_hd__fill_1_249 VSS VDD VDD sky130_fd_sc_hd__fill_1
* cell instance sky130_fd_sc_hd__fill_1_250 r0 *1 0,0
Xsky130_fd_sc_hd__fill_1_250 VSS VDD VDD sky130_fd_sc_hd__fill_1
* cell instance sky130_fd_sc_hd__fill_1_251 r0 *1 0,0
Xsky130_fd_sc_hd__fill_1_251 VSS VDD VDD sky130_fd_sc_hd__fill_1
* cell instance sky130_fd_sc_hd__fill_1_252 r0 *1 0,0
Xsky130_fd_sc_hd__fill_1_252 VSS VDD VDD sky130_fd_sc_hd__fill_1
* cell instance sky130_fd_sc_hd__fill_1_253 r0 *1 0,0
Xsky130_fd_sc_hd__fill_1_253 VSS VDD VDD sky130_fd_sc_hd__fill_1
* cell instance sky130_fd_sc_hd__fill_1_254 r0 *1 0,0
Xsky130_fd_sc_hd__fill_1_254 VSS VDD VDD sky130_fd_sc_hd__fill_1
* cell instance sky130_fd_sc_hd__fill_1_255 r0 *1 0,0
Xsky130_fd_sc_hd__fill_1_255 VSS VDD VDD sky130_fd_sc_hd__fill_1
* cell instance sky130_fd_sc_hd__fill_1_256 r0 *1 0,0
Xsky130_fd_sc_hd__fill_1_256 VSS VDD VDD sky130_fd_sc_hd__fill_1
* cell instance sky130_fd_sc_hd__fill_1_257 r0 *1 0,0
Xsky130_fd_sc_hd__fill_1_257 VSS VDD VDD sky130_fd_sc_hd__fill_1
* cell instance sky130_fd_sc_hd__fill_1_258 r0 *1 0,0
Xsky130_fd_sc_hd__fill_1_258 VSS VDD VDD sky130_fd_sc_hd__fill_1
* cell instance sky130_fd_sc_hd__fill_1_259 r0 *1 0,0
Xsky130_fd_sc_hd__fill_1_259 VSS VDD VDD sky130_fd_sc_hd__fill_1
* cell instance sky130_fd_sc_hd__fill_1_260 r0 *1 0,0
Xsky130_fd_sc_hd__fill_1_260 VSS VDD VDD sky130_fd_sc_hd__fill_1
* cell instance sky130_fd_sc_hd__fill_1_261 r0 *1 0,0
Xsky130_fd_sc_hd__fill_1_261 VSS VDD VDD sky130_fd_sc_hd__fill_1
* cell instance sky130_fd_sc_hd__fill_1_262 r0 *1 0,0
Xsky130_fd_sc_hd__fill_1_262 VSS VDD VDD sky130_fd_sc_hd__fill_1
* cell instance sky130_fd_sc_hd__fill_1_263 r0 *1 0,0
Xsky130_fd_sc_hd__fill_1_263 VSS VDD VDD sky130_fd_sc_hd__fill_1
* cell instance sky130_fd_sc_hd__fill_1_264 r0 *1 0,0
Xsky130_fd_sc_hd__fill_1_264 VSS VDD VDD sky130_fd_sc_hd__fill_1
* cell instance sky130_fd_sc_hd__fill_1_265 r0 *1 0,0
Xsky130_fd_sc_hd__fill_1_265 VSS VDD VDD sky130_fd_sc_hd__fill_1
* cell instance sky130_fd_sc_hd__fill_1_266 r0 *1 0,0
Xsky130_fd_sc_hd__fill_1_266 VSS VDD VDD sky130_fd_sc_hd__fill_1
* cell instance sky130_fd_sc_hd__fill_1_267 r0 *1 0,0
Xsky130_fd_sc_hd__fill_1_267 VSS VDD VDD sky130_fd_sc_hd__fill_1
* cell instance sky130_fd_sc_hd__fill_1_268 r0 *1 0,0
Xsky130_fd_sc_hd__fill_1_268 VSS VDD VDD sky130_fd_sc_hd__fill_1
* cell instance sky130_fd_sc_hd__fill_1_269 r0 *1 0,0
Xsky130_fd_sc_hd__fill_1_269 VSS VDD VDD sky130_fd_sc_hd__fill_1
* cell instance sky130_fd_sc_hd__fill_1_270 r0 *1 0,0
Xsky130_fd_sc_hd__fill_1_270 VSS VDD VDD sky130_fd_sc_hd__fill_1
* cell instance sky130_fd_sc_hd__fill_1_271 r0 *1 0,0
Xsky130_fd_sc_hd__fill_1_271 VSS VDD VDD sky130_fd_sc_hd__fill_1
* cell instance sky130_fd_sc_hd__fill_1_272 r0 *1 0,0
Xsky130_fd_sc_hd__fill_1_272 VSS VDD VDD sky130_fd_sc_hd__fill_1
* cell instance sky130_fd_sc_hd__fill_1_273 r0 *1 0,0
Xsky130_fd_sc_hd__fill_1_273 VSS VDD VDD sky130_fd_sc_hd__fill_1
* cell instance sky130_fd_sc_hd__fill_1_274 r0 *1 0,0
Xsky130_fd_sc_hd__fill_1_274 VSS VDD VDD sky130_fd_sc_hd__fill_1
* cell instance sky130_fd_sc_hd__fill_1_275 r0 *1 0,0
Xsky130_fd_sc_hd__fill_1_275 VSS VDD VDD sky130_fd_sc_hd__fill_1
* cell instance sky130_fd_sc_hd__fill_1_276 r0 *1 0,0
Xsky130_fd_sc_hd__fill_1_276 VSS VDD VDD sky130_fd_sc_hd__fill_1
* cell instance sky130_fd_sc_hd__fill_1_277 r0 *1 0,0
Xsky130_fd_sc_hd__fill_1_277 VSS VDD VDD sky130_fd_sc_hd__fill_1
* cell instance sky130_fd_sc_hd__fill_1_278 r0 *1 0,0
Xsky130_fd_sc_hd__fill_1_278 VSS VDD VDD sky130_fd_sc_hd__fill_1
* cell instance sky130_fd_sc_hd__fill_1_279 r0 *1 0,0
Xsky130_fd_sc_hd__fill_1_279 VSS VDD VDD sky130_fd_sc_hd__fill_1
* cell instance sky130_fd_sc_hd__fill_1_280 r0 *1 0,0
Xsky130_fd_sc_hd__fill_1_280 VSS VDD VDD sky130_fd_sc_hd__fill_1
* cell instance sky130_fd_sc_hd__fill_1_281 r0 *1 0,0
Xsky130_fd_sc_hd__fill_1_281 VSS VDD VDD sky130_fd_sc_hd__fill_1
* cell instance sky130_fd_sc_hd__fill_1_282 r0 *1 0,0
Xsky130_fd_sc_hd__fill_1_282 VSS VDD VDD sky130_fd_sc_hd__fill_1
* cell instance sky130_fd_sc_hd__fill_1_283 r0 *1 0,0
Xsky130_fd_sc_hd__fill_1_283 VSS VDD VDD sky130_fd_sc_hd__fill_1
* cell instance sky130_fd_sc_hd__fill_1_284 r0 *1 0,0
Xsky130_fd_sc_hd__fill_1_284 VSS VDD VDD sky130_fd_sc_hd__fill_1
* cell instance sky130_fd_sc_hd__fill_1_285 r0 *1 0,0
Xsky130_fd_sc_hd__fill_1_285 VSS VDD VDD sky130_fd_sc_hd__fill_1
* cell instance sky130_fd_sc_hd__fill_1_286 r0 *1 0,0
Xsky130_fd_sc_hd__fill_1_286 VSS VDD VDD sky130_fd_sc_hd__fill_1
* cell instance sky130_fd_sc_hd__fill_1_287 r0 *1 0,0
Xsky130_fd_sc_hd__fill_1_287 VSS VDD VDD sky130_fd_sc_hd__fill_1
* cell instance sky130_fd_sc_hd__fill_1_288 r0 *1 0,0
Xsky130_fd_sc_hd__fill_1_288 VSS VDD VDD sky130_fd_sc_hd__fill_1
* cell instance sky130_fd_sc_hd__fill_1_289 r0 *1 0,0
Xsky130_fd_sc_hd__fill_1_289 VSS VDD VDD sky130_fd_sc_hd__fill_1
* cell instance sky130_fd_sc_hd__fill_1_290 r0 *1 0,0
Xsky130_fd_sc_hd__fill_1_290 VSS VDD VDD sky130_fd_sc_hd__fill_1
* cell instance sky130_fd_sc_hd__fill_1_291 r0 *1 0,0
Xsky130_fd_sc_hd__fill_1_291 VSS VDD VDD sky130_fd_sc_hd__fill_1
* cell instance sky130_fd_sc_hd__fill_1_292 r0 *1 0,0
Xsky130_fd_sc_hd__fill_1_292 VSS VDD VDD sky130_fd_sc_hd__fill_1
* cell instance sky130_fd_sc_hd__fill_1_293 r0 *1 0,0
Xsky130_fd_sc_hd__fill_1_293 VSS VDD VDD sky130_fd_sc_hd__fill_1
* cell instance sky130_fd_sc_hd__fill_1_294 r0 *1 0,0
Xsky130_fd_sc_hd__fill_1_294 VSS VDD VDD sky130_fd_sc_hd__fill_1
* cell instance sky130_fd_sc_hd__fill_1_295 r0 *1 0,0
Xsky130_fd_sc_hd__fill_1_295 VSS VDD VDD sky130_fd_sc_hd__fill_1
* cell instance sky130_fd_sc_hd__fill_1_296 r0 *1 0,0
Xsky130_fd_sc_hd__fill_1_296 VSS VDD VDD sky130_fd_sc_hd__fill_1
* cell instance sky130_fd_sc_hd__fill_1_297 r0 *1 0,0
Xsky130_fd_sc_hd__fill_1_297 VSS VDD VDD sky130_fd_sc_hd__fill_1
* cell instance sky130_fd_sc_hd__fill_1_298 r0 *1 0,0
Xsky130_fd_sc_hd__fill_1_298 VSS VDD VDD sky130_fd_sc_hd__fill_1
* cell instance sky130_fd_sc_hd__fill_1_299 r0 *1 0,0
Xsky130_fd_sc_hd__fill_1_299 VSS VDD VDD sky130_fd_sc_hd__fill_1
* cell instance sky130_fd_sc_hd__fill_1_300 r0 *1 0,0
Xsky130_fd_sc_hd__fill_1_300 VSS VDD VDD sky130_fd_sc_hd__fill_1
* cell instance sky130_fd_sc_hd__fill_1_301 r0 *1 0,0
Xsky130_fd_sc_hd__fill_1_301 VSS VDD VDD sky130_fd_sc_hd__fill_1
* cell instance sky130_fd_sc_hd__fill_1_302 r0 *1 0,0
Xsky130_fd_sc_hd__fill_1_302 VSS VDD VDD sky130_fd_sc_hd__fill_1
* cell instance sky130_fd_sc_hd__fill_1_303 r0 *1 0,0
Xsky130_fd_sc_hd__fill_1_303 VSS VDD VDD sky130_fd_sc_hd__fill_1
* cell instance sky130_fd_sc_hd__fill_1_304 r0 *1 0,0
Xsky130_fd_sc_hd__fill_1_304 VSS VDD VDD sky130_fd_sc_hd__fill_1
* cell instance sky130_fd_sc_hd__fill_1_305 r0 *1 0,0
Xsky130_fd_sc_hd__fill_1_305 VSS VDD VDD sky130_fd_sc_hd__fill_1
* cell instance sky130_fd_sc_hd__fill_1_306 r0 *1 0,0
Xsky130_fd_sc_hd__fill_1_306 VSS VDD VDD sky130_fd_sc_hd__fill_1
* cell instance sky130_fd_sc_hd__fill_1_307 r0 *1 0,0
Xsky130_fd_sc_hd__fill_1_307 VSS VDD VDD sky130_fd_sc_hd__fill_1
* cell instance sky130_fd_sc_hd__fill_1_308 r0 *1 0,0
Xsky130_fd_sc_hd__fill_1_308 VSS VDD VDD sky130_fd_sc_hd__fill_1
* cell instance sky130_fd_sc_hd__fill_1_309 r0 *1 0,0
Xsky130_fd_sc_hd__fill_1_309 VSS VDD VDD sky130_fd_sc_hd__fill_1
* cell instance sky130_fd_sc_hd__fill_1_310 r0 *1 0,0
Xsky130_fd_sc_hd__fill_1_310 VSS VDD VDD sky130_fd_sc_hd__fill_1
* cell instance sky130_fd_sc_hd__fill_1_311 r0 *1 0,0
Xsky130_fd_sc_hd__fill_1_311 VSS VDD VDD sky130_fd_sc_hd__fill_1
* cell instance sky130_fd_sc_hd__fill_1_312 r0 *1 0,0
Xsky130_fd_sc_hd__fill_1_312 VSS VDD VDD sky130_fd_sc_hd__fill_1
* cell instance sky130_fd_sc_hd__fill_1_313 r0 *1 0,0
Xsky130_fd_sc_hd__fill_1_313 VSS VDD VDD sky130_fd_sc_hd__fill_1
* cell instance sky130_fd_sc_hd__fill_1_314 r0 *1 0,0
Xsky130_fd_sc_hd__fill_1_314 VSS VDD VDD sky130_fd_sc_hd__fill_1
* cell instance sky130_fd_sc_hd__fill_1_315 r0 *1 0,0
Xsky130_fd_sc_hd__fill_1_315 VSS VDD VDD sky130_fd_sc_hd__fill_1
* cell instance sky130_fd_sc_hd__fill_1_316 r0 *1 0,0
Xsky130_fd_sc_hd__fill_1_316 VSS VDD VDD sky130_fd_sc_hd__fill_1
* cell instance sky130_fd_sc_hd__fill_1_317 r0 *1 0,0
Xsky130_fd_sc_hd__fill_1_317 VSS VDD VDD sky130_fd_sc_hd__fill_1
* cell instance sky130_fd_sc_hd__fill_1_318 r0 *1 0,0
Xsky130_fd_sc_hd__fill_1_318 VSS VDD VDD sky130_fd_sc_hd__fill_1
* cell instance sky130_fd_sc_hd__fill_1_319 r0 *1 0,0
Xsky130_fd_sc_hd__fill_1_319 VSS VDD VDD sky130_fd_sc_hd__fill_1
* cell instance sky130_fd_sc_hd__fill_1_320 r0 *1 0,0
Xsky130_fd_sc_hd__fill_1_320 VSS VDD VDD sky130_fd_sc_hd__fill_1
* cell instance sky130_fd_sc_hd__fill_1_321 r0 *1 0,0
Xsky130_fd_sc_hd__fill_1_321 VSS VDD VDD sky130_fd_sc_hd__fill_1
* cell instance sky130_fd_sc_hd__fill_1_322 r0 *1 0,0
Xsky130_fd_sc_hd__fill_1_322 VSS VDD VDD sky130_fd_sc_hd__fill_1
* cell instance sky130_fd_sc_hd__fill_1_323 r0 *1 0,0
Xsky130_fd_sc_hd__fill_1_323 VSS VDD VDD sky130_fd_sc_hd__fill_1
* cell instance sky130_fd_sc_hd__fill_1_324 r0 *1 0,0
Xsky130_fd_sc_hd__fill_1_324 VSS VDD VDD sky130_fd_sc_hd__fill_1
* cell instance sky130_fd_sc_hd__fill_1_325 r0 *1 0,0
Xsky130_fd_sc_hd__fill_1_325 VSS VDD VDD sky130_fd_sc_hd__fill_1
* cell instance sky130_fd_sc_hd__fill_1_326 r0 *1 0,0
Xsky130_fd_sc_hd__fill_1_326 VSS VDD VDD sky130_fd_sc_hd__fill_1
* cell instance sky130_fd_sc_hd__fill_1_327 r0 *1 0,0
Xsky130_fd_sc_hd__fill_1_327 VSS VDD VDD sky130_fd_sc_hd__fill_1
* cell instance sky130_fd_sc_hd__fill_1_328 r0 *1 0,0
Xsky130_fd_sc_hd__fill_1_328 VSS VDD VDD sky130_fd_sc_hd__fill_1
* cell instance sky130_fd_sc_hd__fill_1_329 r0 *1 0,0
Xsky130_fd_sc_hd__fill_1_329 VSS VDD VDD sky130_fd_sc_hd__fill_1
* cell instance sky130_fd_sc_hd__fill_1_330 r0 *1 0,0
Xsky130_fd_sc_hd__fill_1_330 VSS VDD VDD sky130_fd_sc_hd__fill_1
* cell instance sky130_fd_sc_hd__fill_1_331 r0 *1 0,0
Xsky130_fd_sc_hd__fill_1_331 VSS VDD VDD sky130_fd_sc_hd__fill_1
* cell instance sky130_fd_sc_hd__fill_1_332 r0 *1 0,0
Xsky130_fd_sc_hd__fill_1_332 VSS VDD VDD sky130_fd_sc_hd__fill_1
* cell instance sky130_fd_sc_hd__fill_1_333 r0 *1 0,0
Xsky130_fd_sc_hd__fill_1_333 VSS VDD VDD sky130_fd_sc_hd__fill_1
* cell instance sky130_fd_sc_hd__fill_1_334 r0 *1 0,0
Xsky130_fd_sc_hd__fill_1_334 VSS VDD VDD sky130_fd_sc_hd__fill_1
* cell instance sky130_fd_sc_hd__fill_1_335 r0 *1 0,0
Xsky130_fd_sc_hd__fill_1_335 VSS VDD VDD sky130_fd_sc_hd__fill_1
* cell instance sky130_fd_sc_hd__fill_1_336 r0 *1 0,0
Xsky130_fd_sc_hd__fill_1_336 VSS VDD VDD sky130_fd_sc_hd__fill_1
* cell instance sky130_fd_sc_hd__fill_1_337 r0 *1 0,0
Xsky130_fd_sc_hd__fill_1_337 VSS VDD VDD sky130_fd_sc_hd__fill_1
* cell instance sky130_fd_sc_hd__fill_1_338 r0 *1 0,0
Xsky130_fd_sc_hd__fill_1_338 VSS VDD VDD sky130_fd_sc_hd__fill_1
* cell instance sky130_fd_sc_hd__fill_1_339 r0 *1 0,0
Xsky130_fd_sc_hd__fill_1_339 VSS VDD VDD sky130_fd_sc_hd__fill_1
* cell instance sky130_fd_sc_hd__fill_1_340 r0 *1 0,0
Xsky130_fd_sc_hd__fill_1_340 VSS VDD VDD sky130_fd_sc_hd__fill_1
* cell instance sky130_fd_sc_hd__fill_1_341 r0 *1 0,0
Xsky130_fd_sc_hd__fill_1_341 VSS VDD VDD sky130_fd_sc_hd__fill_1
* cell instance sky130_fd_sc_hd__fill_1_342 r0 *1 0,0
Xsky130_fd_sc_hd__fill_1_342 VSS VDD VDD sky130_fd_sc_hd__fill_1
* cell instance sky130_fd_sc_hd__fill_1_343 r0 *1 0,0
Xsky130_fd_sc_hd__fill_1_343 VSS VDD VDD sky130_fd_sc_hd__fill_1
* cell instance sky130_fd_sc_hd__fill_1_344 r0 *1 0,0
Xsky130_fd_sc_hd__fill_1_344 VSS VDD VDD sky130_fd_sc_hd__fill_1
* cell instance sky130_fd_sc_hd__fill_1_345 r0 *1 0,0
Xsky130_fd_sc_hd__fill_1_345 VSS VDD VDD sky130_fd_sc_hd__fill_1
* cell instance sky130_fd_sc_hd__fill_1_346 r0 *1 0,0
Xsky130_fd_sc_hd__fill_1_346 VSS VDD VDD sky130_fd_sc_hd__fill_1
* cell instance sky130_fd_sc_hd__fill_1_347 r0 *1 0,0
Xsky130_fd_sc_hd__fill_1_347 VSS VDD VDD sky130_fd_sc_hd__fill_1
* cell instance sky130_fd_sc_hd__fill_1_348 r0 *1 0,0
Xsky130_fd_sc_hd__fill_1_348 VSS VDD VDD sky130_fd_sc_hd__fill_1
* cell instance sky130_fd_sc_hd__fill_1_349 r0 *1 0,0
Xsky130_fd_sc_hd__fill_1_349 VSS VDD VDD sky130_fd_sc_hd__fill_1
* cell instance sky130_fd_sc_hd__fill_1_350 r0 *1 0,0
Xsky130_fd_sc_hd__fill_1_350 VSS VDD VDD sky130_fd_sc_hd__fill_1
* cell instance sky130_fd_sc_hd__fill_1_351 r0 *1 0,0
Xsky130_fd_sc_hd__fill_1_351 VSS VDD VDD sky130_fd_sc_hd__fill_1
* cell instance sky130_fd_sc_hd__fill_1_352 r0 *1 0,0
Xsky130_fd_sc_hd__fill_1_352 VSS VDD VDD sky130_fd_sc_hd__fill_1
* cell instance sky130_fd_sc_hd__fill_1_353 r0 *1 0,0
Xsky130_fd_sc_hd__fill_1_353 VSS VDD VDD sky130_fd_sc_hd__fill_1
* cell instance sky130_fd_sc_hd__fill_1_354 r0 *1 0,0
Xsky130_fd_sc_hd__fill_1_354 VSS VDD VDD sky130_fd_sc_hd__fill_1
* cell instance sky130_fd_sc_hd__fill_1_355 r0 *1 0,0
Xsky130_fd_sc_hd__fill_1_355 VSS VDD VDD sky130_fd_sc_hd__fill_1
* cell instance sky130_fd_sc_hd__fill_1_356 r0 *1 0,0
Xsky130_fd_sc_hd__fill_1_356 VSS VDD VDD sky130_fd_sc_hd__fill_1
* cell instance sky130_fd_sc_hd__fill_1_357 r0 *1 0,0
Xsky130_fd_sc_hd__fill_1_357 VSS VDD VDD sky130_fd_sc_hd__fill_1
* cell instance sky130_fd_sc_hd__fill_1_358 r0 *1 0,0
Xsky130_fd_sc_hd__fill_1_358 VSS VDD VDD sky130_fd_sc_hd__fill_1
* cell instance sky130_fd_sc_hd__fill_1_359 r0 *1 0,0
Xsky130_fd_sc_hd__fill_1_359 VSS VDD VDD sky130_fd_sc_hd__fill_1
* cell instance sky130_fd_sc_hd__fill_1_360 r0 *1 0,0
Xsky130_fd_sc_hd__fill_1_360 VSS VDD VDD sky130_fd_sc_hd__fill_1
* cell instance sky130_fd_sc_hd__fill_1_361 r0 *1 0,0
Xsky130_fd_sc_hd__fill_1_361 VSS VDD VDD sky130_fd_sc_hd__fill_1
* cell instance sky130_fd_sc_hd__fill_1_362 r0 *1 0,0
Xsky130_fd_sc_hd__fill_1_362 VSS VDD VDD sky130_fd_sc_hd__fill_1
* cell instance sky130_fd_sc_hd__fill_1_363 r0 *1 0,0
Xsky130_fd_sc_hd__fill_1_363 VSS VDD VDD sky130_fd_sc_hd__fill_1
* cell instance sky130_fd_sc_hd__fill_1_364 r0 *1 0,0
Xsky130_fd_sc_hd__fill_1_364 VSS VDD VDD sky130_fd_sc_hd__fill_1
* cell instance sky130_fd_sc_hd__fill_1_365 r0 *1 0,0
Xsky130_fd_sc_hd__fill_1_365 VSS VDD VDD sky130_fd_sc_hd__fill_1
* cell instance sky130_fd_sc_hd__fill_1_366 r0 *1 0,0
Xsky130_fd_sc_hd__fill_1_366 VSS VDD VDD sky130_fd_sc_hd__fill_1
* cell instance sky130_fd_sc_hd__fill_1_367 r0 *1 0,0
Xsky130_fd_sc_hd__fill_1_367 VSS VDD VDD sky130_fd_sc_hd__fill_1
* cell instance sky130_fd_sc_hd__fill_1_368 r0 *1 0,0
Xsky130_fd_sc_hd__fill_1_368 VSS VDD VDD sky130_fd_sc_hd__fill_1
* cell instance sky130_fd_sc_hd__fill_1_369 r0 *1 0,0
Xsky130_fd_sc_hd__fill_1_369 VSS VDD VDD sky130_fd_sc_hd__fill_1
* cell instance sky130_fd_sc_hd__fill_1_370 r0 *1 0,0
Xsky130_fd_sc_hd__fill_1_370 VSS VDD VDD sky130_fd_sc_hd__fill_1
* cell instance sky130_fd_sc_hd__fill_1_371 r0 *1 0,0
Xsky130_fd_sc_hd__fill_1_371 VSS VDD VDD sky130_fd_sc_hd__fill_1
* cell instance sky130_fd_sc_hd__fill_1_372 r0 *1 0,0
Xsky130_fd_sc_hd__fill_1_372 VSS VDD VDD sky130_fd_sc_hd__fill_1
* cell instance sky130_fd_sc_hd__fill_1_373 r0 *1 0,0
Xsky130_fd_sc_hd__fill_1_373 VSS VDD VDD sky130_fd_sc_hd__fill_1
* cell instance sky130_fd_sc_hd__fill_1_374 r0 *1 0,0
Xsky130_fd_sc_hd__fill_1_374 VSS VDD VDD sky130_fd_sc_hd__fill_1
* cell instance sky130_fd_sc_hd__fill_1_375 r0 *1 0,0
Xsky130_fd_sc_hd__fill_1_375 VSS VDD VDD sky130_fd_sc_hd__fill_1
* cell instance sky130_fd_sc_hd__fill_1_376 r0 *1 0,0
Xsky130_fd_sc_hd__fill_1_376 VSS VDD VDD sky130_fd_sc_hd__fill_1
* cell instance sky130_fd_sc_hd__fill_1_377 r0 *1 0,0
Xsky130_fd_sc_hd__fill_1_377 VSS VDD VDD sky130_fd_sc_hd__fill_1
* cell instance sky130_fd_sc_hd__fill_1_378 r0 *1 0,0
Xsky130_fd_sc_hd__fill_1_378 VSS VDD VDD sky130_fd_sc_hd__fill_1
* cell instance sky130_fd_sc_hd__fill_1_379 r0 *1 0,0
Xsky130_fd_sc_hd__fill_1_379 VSS VDD VDD sky130_fd_sc_hd__fill_1
* cell instance sky130_fd_sc_hd__fill_1_380 r0 *1 0,0
Xsky130_fd_sc_hd__fill_1_380 VSS VDD VDD sky130_fd_sc_hd__fill_1
* cell instance sky130_fd_sc_hd__fill_1_381 r0 *1 0,0
Xsky130_fd_sc_hd__fill_1_381 VSS VDD VDD sky130_fd_sc_hd__fill_1
* cell instance sky130_fd_sc_hd__fill_1_382 r0 *1 0,0
Xsky130_fd_sc_hd__fill_1_382 VSS VDD VDD sky130_fd_sc_hd__fill_1
* cell instance sky130_fd_sc_hd__fill_1_383 r0 *1 0,0
Xsky130_fd_sc_hd__fill_1_383 VSS VDD VDD sky130_fd_sc_hd__fill_1
* cell instance sky130_fd_sc_hd__fill_1_384 r0 *1 0,0
Xsky130_fd_sc_hd__fill_1_384 VSS VDD VDD sky130_fd_sc_hd__fill_1
* cell instance sky130_fd_sc_hd__fill_1_385 r0 *1 0,0
Xsky130_fd_sc_hd__fill_1_385 VSS VDD VDD sky130_fd_sc_hd__fill_1
* cell instance sky130_fd_sc_hd__fill_1_386 r0 *1 0,0
Xsky130_fd_sc_hd__fill_1_386 VSS VDD VDD sky130_fd_sc_hd__fill_1
* cell instance sky130_fd_sc_hd__fill_1_387 r0 *1 0,0
Xsky130_fd_sc_hd__fill_1_387 VSS VDD VDD sky130_fd_sc_hd__fill_1
* cell instance sky130_fd_sc_hd__fill_1_388 r0 *1 0,0
Xsky130_fd_sc_hd__fill_1_388 VSS VDD VDD sky130_fd_sc_hd__fill_1
* cell instance sky130_fd_sc_hd__fill_1_389 r0 *1 0,0
Xsky130_fd_sc_hd__fill_1_389 VSS VDD VDD sky130_fd_sc_hd__fill_1
* cell instance sky130_fd_sc_hd__fill_1_390 r0 *1 0,0
Xsky130_fd_sc_hd__fill_1_390 VSS VDD VDD sky130_fd_sc_hd__fill_1
* cell instance sky130_fd_sc_hd__fill_1_391 r0 *1 0,0
Xsky130_fd_sc_hd__fill_1_391 VSS VDD VDD sky130_fd_sc_hd__fill_1
* cell instance sky130_fd_sc_hd__fill_1_392 r0 *1 0,0
Xsky130_fd_sc_hd__fill_1_392 VSS VDD VDD sky130_fd_sc_hd__fill_1
* cell instance sky130_fd_sc_hd__fill_1_393 r0 *1 0,0
Xsky130_fd_sc_hd__fill_1_393 VSS VDD VDD sky130_fd_sc_hd__fill_1
* cell instance sky130_fd_sc_hd__fill_1_394 r0 *1 0,0
Xsky130_fd_sc_hd__fill_1_394 VSS VDD VDD sky130_fd_sc_hd__fill_1
* cell instance sky130_fd_sc_hd__fill_1_395 r0 *1 0,0
Xsky130_fd_sc_hd__fill_1_395 VSS VDD VDD sky130_fd_sc_hd__fill_1
* cell instance sky130_fd_sc_hd__fill_1_396 r0 *1 0,0
Xsky130_fd_sc_hd__fill_1_396 VSS VDD VDD sky130_fd_sc_hd__fill_1
* cell instance sky130_fd_sc_hd__fill_1_397 r0 *1 0,0
Xsky130_fd_sc_hd__fill_1_397 VSS VDD VDD sky130_fd_sc_hd__fill_1
* cell instance sky130_fd_sc_hd__fill_1_398 r0 *1 0,0
Xsky130_fd_sc_hd__fill_1_398 VSS VDD VDD sky130_fd_sc_hd__fill_1
* cell instance sky130_fd_sc_hd__fill_1_399 r0 *1 0,0
Xsky130_fd_sc_hd__fill_1_399 VSS VDD VDD sky130_fd_sc_hd__fill_1
* cell instance sky130_fd_sc_hd__fill_1_400 r0 *1 0,0
Xsky130_fd_sc_hd__fill_1_400 VSS VDD VDD sky130_fd_sc_hd__fill_1
* cell instance sky130_fd_sc_hd__fill_1_401 r0 *1 0,0
Xsky130_fd_sc_hd__fill_1_401 VSS VDD VDD sky130_fd_sc_hd__fill_1
* cell instance sky130_fd_sc_hd__fill_1_402 r0 *1 0,0
Xsky130_fd_sc_hd__fill_1_402 VSS VDD VDD sky130_fd_sc_hd__fill_1
* cell instance sky130_fd_sc_hd__fill_1_403 r0 *1 0,0
Xsky130_fd_sc_hd__fill_1_403 VSS VDD VDD sky130_fd_sc_hd__fill_1
* cell instance sky130_fd_sc_hd__fill_1_404 r0 *1 0,0
Xsky130_fd_sc_hd__fill_1_404 VSS VDD VDD sky130_fd_sc_hd__fill_1
* cell instance sky130_fd_sc_hd__fill_1_405 r0 *1 0,0
Xsky130_fd_sc_hd__fill_1_405 VSS VDD VDD sky130_fd_sc_hd__fill_1
* cell instance sky130_fd_sc_hd__fill_1_406 r0 *1 0,0
Xsky130_fd_sc_hd__fill_1_406 VSS VDD VDD sky130_fd_sc_hd__fill_1
* cell instance sky130_fd_sc_hd__fill_1_407 r0 *1 0,0
Xsky130_fd_sc_hd__fill_1_407 VSS VDD VDD sky130_fd_sc_hd__fill_1
* cell instance sky130_fd_sc_hd__fill_1_408 r0 *1 0,0
Xsky130_fd_sc_hd__fill_1_408 VSS VDD VDD sky130_fd_sc_hd__fill_1
* cell instance sky130_fd_sc_hd__fill_1_409 r0 *1 0,0
Xsky130_fd_sc_hd__fill_1_409 VSS VDD VDD sky130_fd_sc_hd__fill_1
* cell instance sky130_fd_sc_hd__fill_1_410 r0 *1 0,0
Xsky130_fd_sc_hd__fill_1_410 VSS VDD VDD sky130_fd_sc_hd__fill_1
* cell instance sky130_fd_sc_hd__fill_1_411 r0 *1 0,0
Xsky130_fd_sc_hd__fill_1_411 VSS VDD VDD sky130_fd_sc_hd__fill_1
* cell instance sky130_fd_sc_hd__fill_1_412 r0 *1 0,0
Xsky130_fd_sc_hd__fill_1_412 VSS VDD VDD sky130_fd_sc_hd__fill_1
* cell instance sky130_fd_sc_hd__fill_1_413 r0 *1 0,0
Xsky130_fd_sc_hd__fill_1_413 VSS VDD VDD sky130_fd_sc_hd__fill_1
* cell instance sky130_fd_sc_hd__fill_1_414 r0 *1 0,0
Xsky130_fd_sc_hd__fill_1_414 VSS VDD VDD sky130_fd_sc_hd__fill_1
* cell instance sky130_fd_sc_hd__fill_1_415 r0 *1 0,0
Xsky130_fd_sc_hd__fill_1_415 VSS VDD VDD sky130_fd_sc_hd__fill_1
* cell instance sky130_fd_sc_hd__fill_1_416 r0 *1 0,0
Xsky130_fd_sc_hd__fill_1_416 VSS VDD VDD sky130_fd_sc_hd__fill_1
* cell instance sky130_fd_sc_hd__fill_1_417 r0 *1 0,0
Xsky130_fd_sc_hd__fill_1_417 VSS VDD VDD sky130_fd_sc_hd__fill_1
* cell instance sky130_fd_sc_hd__fill_1_418 r0 *1 0,0
Xsky130_fd_sc_hd__fill_1_418 VSS VDD VDD sky130_fd_sc_hd__fill_1
* cell instance sky130_fd_sc_hd__fill_1_419 r0 *1 0,0
Xsky130_fd_sc_hd__fill_1_419 VSS VDD VDD sky130_fd_sc_hd__fill_1
* cell instance sky130_fd_sc_hd__fill_1_420 r0 *1 0,0
Xsky130_fd_sc_hd__fill_1_420 VSS VDD VDD sky130_fd_sc_hd__fill_1
* cell instance sky130_fd_sc_hd__fill_1_421 r0 *1 0,0
Xsky130_fd_sc_hd__fill_1_421 VSS VDD VDD sky130_fd_sc_hd__fill_1
* cell instance sky130_fd_sc_hd__fill_1_422 r0 *1 0,0
Xsky130_fd_sc_hd__fill_1_422 VSS VDD VDD sky130_fd_sc_hd__fill_1
* cell instance sky130_fd_sc_hd__fill_1_423 r0 *1 0,0
Xsky130_fd_sc_hd__fill_1_423 VSS VDD VDD sky130_fd_sc_hd__fill_1
* cell instance sky130_fd_sc_hd__fill_1_424 r0 *1 0,0
Xsky130_fd_sc_hd__fill_1_424 VSS VDD VDD sky130_fd_sc_hd__fill_1
* cell instance sky130_fd_sc_hd__fill_1_425 r0 *1 0,0
Xsky130_fd_sc_hd__fill_1_425 VSS VDD VDD sky130_fd_sc_hd__fill_1
* cell instance sky130_fd_sc_hd__fill_1_426 r0 *1 0,0
Xsky130_fd_sc_hd__fill_1_426 VSS VDD VDD sky130_fd_sc_hd__fill_1
* cell instance sky130_fd_sc_hd__fill_1_427 r0 *1 0,0
Xsky130_fd_sc_hd__fill_1_427 VSS VDD VDD sky130_fd_sc_hd__fill_1
* cell instance sky130_fd_sc_hd__fill_1_428 r0 *1 0,0
Xsky130_fd_sc_hd__fill_1_428 VSS VDD VDD sky130_fd_sc_hd__fill_1
* cell instance sky130_fd_sc_hd__fill_1_429 r0 *1 0,0
Xsky130_fd_sc_hd__fill_1_429 VSS VDD VDD sky130_fd_sc_hd__fill_1
* cell instance sky130_fd_sc_hd__fill_1_430 r0 *1 0,0
Xsky130_fd_sc_hd__fill_1_430 VSS VDD VDD sky130_fd_sc_hd__fill_1
* cell instance sky130_fd_sc_hd__fill_1_431 r0 *1 0,0
Xsky130_fd_sc_hd__fill_1_431 VSS VDD VDD sky130_fd_sc_hd__fill_1
* cell instance sky130_fd_sc_hd__fill_1_432 r0 *1 0,0
Xsky130_fd_sc_hd__fill_1_432 VSS VDD VDD sky130_fd_sc_hd__fill_1
* cell instance sky130_fd_sc_hd__fill_1_433 r0 *1 0,0
Xsky130_fd_sc_hd__fill_1_433 VSS VDD VDD sky130_fd_sc_hd__fill_1
* cell instance sky130_fd_sc_hd__fill_1_434 r0 *1 0,0
Xsky130_fd_sc_hd__fill_1_434 VSS VDD VDD sky130_fd_sc_hd__fill_1
* cell instance sky130_fd_sc_hd__fill_1_435 r0 *1 0,0
Xsky130_fd_sc_hd__fill_1_435 VSS VDD VDD sky130_fd_sc_hd__fill_1
* cell instance sky130_fd_sc_hd__fill_1_436 r0 *1 0,0
Xsky130_fd_sc_hd__fill_1_436 VSS VDD VDD sky130_fd_sc_hd__fill_1
* cell instance sky130_fd_sc_hd__fill_1_437 r0 *1 0,0
Xsky130_fd_sc_hd__fill_1_437 VSS VDD VDD sky130_fd_sc_hd__fill_1
* cell instance sky130_fd_sc_hd__fill_1_438 r0 *1 0,0
Xsky130_fd_sc_hd__fill_1_438 VSS VDD VDD sky130_fd_sc_hd__fill_1
* cell instance sky130_fd_sc_hd__fill_1_439 r0 *1 0,0
Xsky130_fd_sc_hd__fill_1_439 VSS VDD VDD sky130_fd_sc_hd__fill_1
* cell instance sky130_fd_sc_hd__fill_1_440 r0 *1 0,0
Xsky130_fd_sc_hd__fill_1_440 VSS VDD VDD sky130_fd_sc_hd__fill_1
* cell instance sky130_fd_sc_hd__fill_1_441 r0 *1 0,0
Xsky130_fd_sc_hd__fill_1_441 VSS VDD VDD sky130_fd_sc_hd__fill_1
* cell instance sky130_fd_sc_hd__fill_1_442 r0 *1 0,0
Xsky130_fd_sc_hd__fill_1_442 VSS VDD VDD sky130_fd_sc_hd__fill_1
* cell instance sky130_fd_sc_hd__fill_1_443 r0 *1 0,0
Xsky130_fd_sc_hd__fill_1_443 VSS VDD VDD sky130_fd_sc_hd__fill_1
* cell instance sky130_fd_sc_hd__fill_1_444 r0 *1 0,0
Xsky130_fd_sc_hd__fill_1_444 VSS VDD VDD sky130_fd_sc_hd__fill_1
* cell instance sky130_fd_sc_hd__fill_1_445 r0 *1 0,0
Xsky130_fd_sc_hd__fill_1_445 VSS VDD VDD sky130_fd_sc_hd__fill_1
* cell instance sky130_fd_sc_hd__fill_1_446 r0 *1 0,0
Xsky130_fd_sc_hd__fill_1_446 VSS VDD VDD sky130_fd_sc_hd__fill_1
* cell instance sky130_fd_sc_hd__fill_1_447 r0 *1 0,0
Xsky130_fd_sc_hd__fill_1_447 VSS VDD VDD sky130_fd_sc_hd__fill_1
* cell instance sky130_fd_sc_hd__fill_1_448 r0 *1 0,0
Xsky130_fd_sc_hd__fill_1_448 VSS VDD VDD sky130_fd_sc_hd__fill_1
* cell instance sky130_fd_sc_hd__fill_1_449 r0 *1 0,0
Xsky130_fd_sc_hd__fill_1_449 VSS VDD VDD sky130_fd_sc_hd__fill_1
* cell instance sky130_fd_sc_hd__fill_1_450 r0 *1 0,0
Xsky130_fd_sc_hd__fill_1_450 VSS VDD VDD sky130_fd_sc_hd__fill_1
* cell instance sky130_fd_sc_hd__fill_1_451 r0 *1 0,0
Xsky130_fd_sc_hd__fill_1_451 VSS VDD VDD sky130_fd_sc_hd__fill_1
* cell instance sky130_fd_sc_hd__fill_1_452 r0 *1 0,0
Xsky130_fd_sc_hd__fill_1_452 VSS VDD VDD sky130_fd_sc_hd__fill_1
* cell instance sky130_fd_sc_hd__fill_1_453 r0 *1 0,0
Xsky130_fd_sc_hd__fill_1_453 VSS VDD VDD sky130_fd_sc_hd__fill_1
* cell instance sky130_fd_sc_hd__fill_1_454 r0 *1 0,0
Xsky130_fd_sc_hd__fill_1_454 VSS VDD VDD sky130_fd_sc_hd__fill_1
* cell instance sky130_fd_sc_hd__fill_1_455 r0 *1 0,0
Xsky130_fd_sc_hd__fill_1_455 VSS VDD VDD sky130_fd_sc_hd__fill_1
* cell instance sky130_fd_sc_hd__fill_1_456 r0 *1 0,0
Xsky130_fd_sc_hd__fill_1_456 VSS VDD VDD sky130_fd_sc_hd__fill_1
* cell instance sky130_fd_sc_hd__fill_1_457 r0 *1 0,0
Xsky130_fd_sc_hd__fill_1_457 VSS VDD VDD sky130_fd_sc_hd__fill_1
* cell instance sky130_fd_sc_hd__fill_1_458 r0 *1 0,0
Xsky130_fd_sc_hd__fill_1_458 VSS VDD VDD sky130_fd_sc_hd__fill_1
* cell instance sky130_fd_sc_hd__fill_1_459 r0 *1 0,0
Xsky130_fd_sc_hd__fill_1_459 VSS VDD VDD sky130_fd_sc_hd__fill_1
* cell instance sky130_fd_sc_hd__fill_1_460 r0 *1 0,0
Xsky130_fd_sc_hd__fill_1_460 VSS VDD VDD sky130_fd_sc_hd__fill_1
* cell instance sky130_fd_sc_hd__fill_1_461 r0 *1 0,0
Xsky130_fd_sc_hd__fill_1_461 VSS VDD VDD sky130_fd_sc_hd__fill_1
* cell instance sky130_fd_sc_hd__fill_1_462 r0 *1 0,0
Xsky130_fd_sc_hd__fill_1_462 VSS VDD VDD sky130_fd_sc_hd__fill_1
* cell instance sky130_fd_sc_hd__fill_1_463 r0 *1 0,0
Xsky130_fd_sc_hd__fill_1_463 VSS VDD VDD sky130_fd_sc_hd__fill_1
* cell instance sky130_fd_sc_hd__fill_1_464 r0 *1 0,0
Xsky130_fd_sc_hd__fill_1_464 VSS VDD VDD sky130_fd_sc_hd__fill_1
* cell instance sky130_fd_sc_hd__fill_1_465 r0 *1 0,0
Xsky130_fd_sc_hd__fill_1_465 VSS VDD VDD sky130_fd_sc_hd__fill_1
* cell instance sky130_fd_sc_hd__fill_1_466 r0 *1 0,0
Xsky130_fd_sc_hd__fill_1_466 VSS VDD VDD sky130_fd_sc_hd__fill_1
* cell instance sky130_fd_sc_hd__fill_1_467 r0 *1 0,0
Xsky130_fd_sc_hd__fill_1_467 VSS VDD VDD sky130_fd_sc_hd__fill_1
* cell instance sky130_fd_sc_hd__fill_1_468 r0 *1 0,0
Xsky130_fd_sc_hd__fill_1_468 VSS VDD VDD sky130_fd_sc_hd__fill_1
* cell instance sky130_fd_sc_hd__fill_1_469 r0 *1 0,0
Xsky130_fd_sc_hd__fill_1_469 VSS VDD VDD sky130_fd_sc_hd__fill_1
* cell instance sky130_fd_sc_hd__fill_1_470 r0 *1 0,0
Xsky130_fd_sc_hd__fill_1_470 VSS VDD VDD sky130_fd_sc_hd__fill_1
* cell instance sky130_fd_sc_hd__fill_1_471 r0 *1 0,0
Xsky130_fd_sc_hd__fill_1_471 VSS VDD VDD sky130_fd_sc_hd__fill_1
* cell instance sky130_fd_sc_hd__fill_1_472 r0 *1 0,0
Xsky130_fd_sc_hd__fill_1_472 VSS VDD VDD sky130_fd_sc_hd__fill_1
* cell instance sky130_fd_sc_hd__fill_1_473 r0 *1 0,0
Xsky130_fd_sc_hd__fill_1_473 VSS VDD VDD sky130_fd_sc_hd__fill_1
* cell instance sky130_fd_sc_hd__fill_1_474 r0 *1 0,0
Xsky130_fd_sc_hd__fill_1_474 VSS VDD VDD sky130_fd_sc_hd__fill_1
* cell instance sky130_fd_sc_hd__fill_1_475 r0 *1 0,0
Xsky130_fd_sc_hd__fill_1_475 VSS VDD VDD sky130_fd_sc_hd__fill_1
* cell instance sky130_fd_sc_hd__fill_1_476 r0 *1 0,0
Xsky130_fd_sc_hd__fill_1_476 VSS VDD VDD sky130_fd_sc_hd__fill_1
* cell instance sky130_fd_sc_hd__fill_1_477 r0 *1 0,0
Xsky130_fd_sc_hd__fill_1_477 VSS VDD VDD sky130_fd_sc_hd__fill_1
* cell instance sky130_fd_sc_hd__fill_1_478 r0 *1 0,0
Xsky130_fd_sc_hd__fill_1_478 VSS VDD VDD sky130_fd_sc_hd__fill_1
* cell instance sky130_fd_sc_hd__fill_1_479 r0 *1 0,0
Xsky130_fd_sc_hd__fill_1_479 VSS VDD VDD sky130_fd_sc_hd__fill_1
* cell instance sky130_fd_sc_hd__fill_1_480 r0 *1 0,0
Xsky130_fd_sc_hd__fill_1_480 VSS VDD VDD sky130_fd_sc_hd__fill_1
* cell instance sky130_fd_sc_hd__fill_1_481 r0 *1 0,0
Xsky130_fd_sc_hd__fill_1_481 VSS VDD VDD sky130_fd_sc_hd__fill_1
* cell instance sky130_fd_sc_hd__fill_1_482 r0 *1 0,0
Xsky130_fd_sc_hd__fill_1_482 VSS VDD VDD sky130_fd_sc_hd__fill_1
* cell instance sky130_fd_sc_hd__fill_1_483 r0 *1 0,0
Xsky130_fd_sc_hd__fill_1_483 VSS VDD VDD sky130_fd_sc_hd__fill_1
* cell instance sky130_fd_sc_hd__fill_1_484 r0 *1 0,0
Xsky130_fd_sc_hd__fill_1_484 VSS VDD VDD sky130_fd_sc_hd__fill_1
* cell instance sky130_fd_sc_hd__fill_1_485 r0 *1 0,0
Xsky130_fd_sc_hd__fill_1_485 VSS VDD VDD sky130_fd_sc_hd__fill_1
* cell instance sky130_fd_sc_hd__fill_1_486 r0 *1 0,0
Xsky130_fd_sc_hd__fill_1_486 VSS VDD VDD sky130_fd_sc_hd__fill_1
* cell instance sky130_fd_sc_hd__fill_1_487 r0 *1 0,0
Xsky130_fd_sc_hd__fill_1_487 VSS VDD VDD sky130_fd_sc_hd__fill_1
* cell instance sky130_fd_sc_hd__fill_1_488 r0 *1 0,0
Xsky130_fd_sc_hd__fill_1_488 VSS VDD VDD sky130_fd_sc_hd__fill_1
* cell instance sky130_fd_sc_hd__fill_1_489 r0 *1 0,0
Xsky130_fd_sc_hd__fill_1_489 VSS VDD VDD sky130_fd_sc_hd__fill_1
* cell instance sky130_fd_sc_hd__fill_1_490 r0 *1 0,0
Xsky130_fd_sc_hd__fill_1_490 VSS VDD VDD sky130_fd_sc_hd__fill_1
* cell instance sky130_fd_sc_hd__fill_1_491 r0 *1 0,0
Xsky130_fd_sc_hd__fill_1_491 VSS VDD VDD sky130_fd_sc_hd__fill_1
* cell instance sky130_fd_sc_hd__fill_1_492 r0 *1 0,0
Xsky130_fd_sc_hd__fill_1_492 VSS VDD VDD sky130_fd_sc_hd__fill_1
* cell instance sky130_fd_sc_hd__fill_1_493 r0 *1 0,0
Xsky130_fd_sc_hd__fill_1_493 VSS VDD VDD sky130_fd_sc_hd__fill_1
* cell instance sky130_fd_sc_hd__fill_1_494 r0 *1 0,0
Xsky130_fd_sc_hd__fill_1_494 VSS VDD VDD sky130_fd_sc_hd__fill_1
* cell instance sky130_fd_sc_hd__fill_1_495 r0 *1 0,0
Xsky130_fd_sc_hd__fill_1_495 VSS VDD VDD sky130_fd_sc_hd__fill_1
* cell instance sky130_fd_sc_hd__fill_1_496 r0 *1 0,0
Xsky130_fd_sc_hd__fill_1_496 VSS VDD VDD sky130_fd_sc_hd__fill_1
* cell instance sky130_fd_sc_hd__fill_1_497 r0 *1 0,0
Xsky130_fd_sc_hd__fill_1_497 VSS VDD VDD sky130_fd_sc_hd__fill_1
* cell instance sky130_fd_sc_hd__fill_1_498 r0 *1 0,0
Xsky130_fd_sc_hd__fill_1_498 VSS VDD VDD sky130_fd_sc_hd__fill_1
* cell instance sky130_fd_sc_hd__fill_1_499 r0 *1 0,0
Xsky130_fd_sc_hd__fill_1_499 VSS VDD VDD sky130_fd_sc_hd__fill_1
* cell instance sky130_fd_sc_hd__fill_1_500 r0 *1 0,0
Xsky130_fd_sc_hd__fill_1_500 VSS VDD VDD sky130_fd_sc_hd__fill_1
* cell instance sky130_fd_sc_hd__fill_1_501 r0 *1 0,0
Xsky130_fd_sc_hd__fill_1_501 VSS VDD VDD sky130_fd_sc_hd__fill_1
* cell instance sky130_fd_sc_hd__fill_1_502 r0 *1 0,0
Xsky130_fd_sc_hd__fill_1_502 VSS VDD VDD sky130_fd_sc_hd__fill_1
* cell instance sky130_fd_sc_hd__fill_1_503 r0 *1 0,0
Xsky130_fd_sc_hd__fill_1_503 VSS VDD VDD sky130_fd_sc_hd__fill_1
* cell instance sky130_fd_sc_hd__fill_1_504 r0 *1 0,0
Xsky130_fd_sc_hd__fill_1_504 VSS VDD VDD sky130_fd_sc_hd__fill_1
* cell instance sky130_fd_sc_hd__fill_1_505 r0 *1 0,0
Xsky130_fd_sc_hd__fill_1_505 VSS VDD VDD sky130_fd_sc_hd__fill_1
* cell instance sky130_fd_sc_hd__fill_1_506 r0 *1 0,0
Xsky130_fd_sc_hd__fill_1_506 VSS VDD VDD sky130_fd_sc_hd__fill_1
* cell instance sky130_fd_sc_hd__fill_1_507 r0 *1 0,0
Xsky130_fd_sc_hd__fill_1_507 VSS VDD VDD sky130_fd_sc_hd__fill_1
* cell instance sky130_fd_sc_hd__fill_1_508 r0 *1 0,0
Xsky130_fd_sc_hd__fill_1_508 VSS VDD VDD sky130_fd_sc_hd__fill_1
* cell instance sky130_fd_sc_hd__fill_1_509 r0 *1 0,0
Xsky130_fd_sc_hd__fill_1_509 VSS VDD VDD sky130_fd_sc_hd__fill_1
* cell instance sky130_fd_sc_hd__fill_1_510 r0 *1 0,0
Xsky130_fd_sc_hd__fill_1_510 VSS VDD VDD sky130_fd_sc_hd__fill_1
* cell instance sky130_fd_sc_hd__fill_1_511 r0 *1 0,0
Xsky130_fd_sc_hd__fill_1_511 VSS VDD VDD sky130_fd_sc_hd__fill_1
* cell instance sky130_fd_sc_hd__fill_1_512 r0 *1 0,0
Xsky130_fd_sc_hd__fill_1_512 VSS VDD VDD sky130_fd_sc_hd__fill_1
* cell instance sky130_fd_sc_hd__fill_1_513 r0 *1 0,0
Xsky130_fd_sc_hd__fill_1_513 VSS VDD VDD sky130_fd_sc_hd__fill_1
* cell instance sky130_fd_sc_hd__fill_1_514 r0 *1 0,0
Xsky130_fd_sc_hd__fill_1_514 VSS VDD VDD sky130_fd_sc_hd__fill_1
* cell instance sky130_fd_sc_hd__fill_1_515 r0 *1 0,0
Xsky130_fd_sc_hd__fill_1_515 VSS VDD VDD sky130_fd_sc_hd__fill_1
* cell instance sky130_fd_sc_hd__fill_1_516 r0 *1 0,0
Xsky130_fd_sc_hd__fill_1_516 VSS VDD VDD sky130_fd_sc_hd__fill_1
* cell instance sky130_fd_sc_hd__fill_1_517 r0 *1 0,0
Xsky130_fd_sc_hd__fill_1_517 VSS VDD VDD sky130_fd_sc_hd__fill_1
* cell instance sky130_fd_sc_hd__fill_1_518 r0 *1 0,0
Xsky130_fd_sc_hd__fill_1_518 VSS VDD VDD sky130_fd_sc_hd__fill_1
* cell instance sky130_fd_sc_hd__fill_1_519 r0 *1 0,0
Xsky130_fd_sc_hd__fill_1_519 VSS VDD VDD sky130_fd_sc_hd__fill_1
* cell instance sky130_fd_sc_hd__fill_1_520 r0 *1 0,0
Xsky130_fd_sc_hd__fill_1_520 VSS VDD VDD sky130_fd_sc_hd__fill_1
* cell instance sky130_fd_sc_hd__fill_1_521 r0 *1 0,0
Xsky130_fd_sc_hd__fill_1_521 VSS VDD VDD sky130_fd_sc_hd__fill_1
* cell instance sky130_fd_sc_hd__fill_1_522 r0 *1 0,0
Xsky130_fd_sc_hd__fill_1_522 VSS VDD VDD sky130_fd_sc_hd__fill_1
* cell instance sky130_fd_sc_hd__fill_1_523 r0 *1 0,0
Xsky130_fd_sc_hd__fill_1_523 VSS VDD VDD sky130_fd_sc_hd__fill_1
* cell instance sky130_fd_sc_hd__fill_1_524 r0 *1 0,0
Xsky130_fd_sc_hd__fill_1_524 VSS VDD VDD sky130_fd_sc_hd__fill_1
* cell instance sky130_fd_sc_hd__fill_1_525 r0 *1 0,0
Xsky130_fd_sc_hd__fill_1_525 VSS VDD VDD sky130_fd_sc_hd__fill_1
* cell instance sky130_fd_sc_hd__fill_1_526 r0 *1 0,0
Xsky130_fd_sc_hd__fill_1_526 VSS VDD VDD sky130_fd_sc_hd__fill_1
* cell instance sky130_fd_sc_hd__fill_1_527 r0 *1 0,0
Xsky130_fd_sc_hd__fill_1_527 VSS VDD VDD sky130_fd_sc_hd__fill_1
* cell instance sky130_fd_sc_hd__fill_1_528 r0 *1 0,0
Xsky130_fd_sc_hd__fill_1_528 VSS VDD VDD sky130_fd_sc_hd__fill_1
* cell instance sky130_fd_sc_hd__fill_1_529 r0 *1 0,0
Xsky130_fd_sc_hd__fill_1_529 VSS VDD VDD sky130_fd_sc_hd__fill_1
* cell instance sky130_fd_sc_hd__fill_1_530 r0 *1 0,0
Xsky130_fd_sc_hd__fill_1_530 VSS VDD VDD sky130_fd_sc_hd__fill_1
* cell instance sky130_fd_sc_hd__fill_1_531 r0 *1 0,0
Xsky130_fd_sc_hd__fill_1_531 VSS VDD VDD sky130_fd_sc_hd__fill_1
* cell instance sky130_fd_sc_hd__fill_1_532 r0 *1 0,0
Xsky130_fd_sc_hd__fill_1_532 VSS VDD VDD sky130_fd_sc_hd__fill_1
* cell instance sky130_fd_sc_hd__fill_1_533 r0 *1 0,0
Xsky130_fd_sc_hd__fill_1_533 VSS VDD VDD sky130_fd_sc_hd__fill_1
* cell instance sky130_fd_sc_hd__fill_1_534 r0 *1 0,0
Xsky130_fd_sc_hd__fill_1_534 VSS VDD VDD sky130_fd_sc_hd__fill_1
* cell instance sky130_fd_sc_hd__fill_1_535 r0 *1 0,0
Xsky130_fd_sc_hd__fill_1_535 VSS VDD VDD sky130_fd_sc_hd__fill_1
* cell instance sky130_fd_sc_hd__fill_1_536 r0 *1 0,0
Xsky130_fd_sc_hd__fill_1_536 VSS VDD VDD sky130_fd_sc_hd__fill_1
* cell instance sky130_fd_sc_hd__fill_1_537 r0 *1 0,0
Xsky130_fd_sc_hd__fill_1_537 VSS VDD VDD sky130_fd_sc_hd__fill_1
* cell instance sky130_fd_sc_hd__fill_1_538 r0 *1 0,0
Xsky130_fd_sc_hd__fill_1_538 VSS VDD VDD sky130_fd_sc_hd__fill_1
* cell instance sky130_fd_sc_hd__fill_1_539 r0 *1 0,0
Xsky130_fd_sc_hd__fill_1_539 VSS VDD VDD sky130_fd_sc_hd__fill_1
* cell instance sky130_fd_sc_hd__fill_1_540 r0 *1 0,0
Xsky130_fd_sc_hd__fill_1_540 VSS VDD VDD sky130_fd_sc_hd__fill_1
* cell instance sky130_fd_sc_hd__fill_1_541 r0 *1 0,0
Xsky130_fd_sc_hd__fill_1_541 VSS VDD VDD sky130_fd_sc_hd__fill_1
* cell instance sky130_fd_sc_hd__fill_1_542 r0 *1 0,0
Xsky130_fd_sc_hd__fill_1_542 VSS VDD VDD sky130_fd_sc_hd__fill_1
* cell instance sky130_fd_sc_hd__fill_1_543 r0 *1 0,0
Xsky130_fd_sc_hd__fill_1_543 VSS VDD VDD sky130_fd_sc_hd__fill_1
* cell instance sky130_fd_sc_hd__fill_1_544 r0 *1 0,0
Xsky130_fd_sc_hd__fill_1_544 VSS VDD VDD sky130_fd_sc_hd__fill_1
* cell instance sky130_fd_sc_hd__fill_1_545 r0 *1 0,0
Xsky130_fd_sc_hd__fill_1_545 VSS VDD VDD sky130_fd_sc_hd__fill_1
* cell instance sky130_fd_sc_hd__fill_1_546 r0 *1 0,0
Xsky130_fd_sc_hd__fill_1_546 VSS VDD VDD sky130_fd_sc_hd__fill_1
* cell instance sky130_fd_sc_hd__fill_1_547 r0 *1 0,0
Xsky130_fd_sc_hd__fill_1_547 VSS VDD VDD sky130_fd_sc_hd__fill_1
* cell instance sky130_fd_sc_hd__fill_1_548 r0 *1 0,0
Xsky130_fd_sc_hd__fill_1_548 VSS VDD VDD sky130_fd_sc_hd__fill_1
* cell instance sky130_fd_sc_hd__fill_1_549 r0 *1 0,0
Xsky130_fd_sc_hd__fill_1_549 VSS VDD VDD sky130_fd_sc_hd__fill_1
* cell instance sky130_fd_sc_hd__fill_1_550 r0 *1 0,0
Xsky130_fd_sc_hd__fill_1_550 VSS VDD VDD sky130_fd_sc_hd__fill_1
* cell instance sky130_fd_sc_hd__fill_1_551 r0 *1 0,0
Xsky130_fd_sc_hd__fill_1_551 VSS VDD VDD sky130_fd_sc_hd__fill_1
* cell instance sky130_fd_sc_hd__fill_1_552 r0 *1 0,0
Xsky130_fd_sc_hd__fill_1_552 VSS VDD VDD sky130_fd_sc_hd__fill_1
* cell instance sky130_fd_sc_hd__fill_1_553 r0 *1 0,0
Xsky130_fd_sc_hd__fill_1_553 VSS VDD VDD sky130_fd_sc_hd__fill_1
* cell instance sky130_fd_sc_hd__fill_1_554 r0 *1 0,0
Xsky130_fd_sc_hd__fill_1_554 VSS VDD VDD sky130_fd_sc_hd__fill_1
* cell instance sky130_fd_sc_hd__fill_1_555 r0 *1 0,0
Xsky130_fd_sc_hd__fill_1_555 VSS VDD VDD sky130_fd_sc_hd__fill_1
* cell instance sky130_fd_sc_hd__fill_1_556 r0 *1 0,0
Xsky130_fd_sc_hd__fill_1_556 VSS VDD VDD sky130_fd_sc_hd__fill_1
* cell instance sky130_fd_sc_hd__fill_1_557 r0 *1 0,0
Xsky130_fd_sc_hd__fill_1_557 VSS VDD VDD sky130_fd_sc_hd__fill_1
* cell instance sky130_fd_sc_hd__fill_1_558 r0 *1 0,0
Xsky130_fd_sc_hd__fill_1_558 VSS VDD VDD sky130_fd_sc_hd__fill_1
* cell instance sky130_fd_sc_hd__fill_1_559 r0 *1 0,0
Xsky130_fd_sc_hd__fill_1_559 VSS VDD VDD sky130_fd_sc_hd__fill_1
* cell instance sky130_fd_sc_hd__fill_1_560 r0 *1 0,0
Xsky130_fd_sc_hd__fill_1_560 VSS VDD VDD sky130_fd_sc_hd__fill_1
* cell instance sky130_fd_sc_hd__fill_1_561 r0 *1 0,0
Xsky130_fd_sc_hd__fill_1_561 VSS VDD VDD sky130_fd_sc_hd__fill_1
* cell instance sky130_fd_sc_hd__fill_1_562 r0 *1 0,0
Xsky130_fd_sc_hd__fill_1_562 VSS VDD VDD sky130_fd_sc_hd__fill_1
* cell instance sky130_fd_sc_hd__fill_1_563 r0 *1 0,0
Xsky130_fd_sc_hd__fill_1_563 VSS VDD VDD sky130_fd_sc_hd__fill_1
* cell instance sky130_fd_sc_hd__fill_1_564 r0 *1 0,0
Xsky130_fd_sc_hd__fill_1_564 VSS VDD VDD sky130_fd_sc_hd__fill_1
* cell instance sky130_fd_sc_hd__fill_1_565 r0 *1 0,0
Xsky130_fd_sc_hd__fill_1_565 VSS VDD VDD sky130_fd_sc_hd__fill_1
* cell instance sky130_fd_sc_hd__fill_1_566 r0 *1 0,0
Xsky130_fd_sc_hd__fill_1_566 VSS VDD VDD sky130_fd_sc_hd__fill_1
* cell instance sky130_fd_sc_hd__fill_1_567 r0 *1 0,0
Xsky130_fd_sc_hd__fill_1_567 VSS VDD VDD sky130_fd_sc_hd__fill_1
* cell instance sky130_fd_sc_hd__fill_1_568 r0 *1 0,0
Xsky130_fd_sc_hd__fill_1_568 VSS VDD VDD sky130_fd_sc_hd__fill_1
* cell instance sky130_fd_sc_hd__fill_1_569 r0 *1 0,0
Xsky130_fd_sc_hd__fill_1_569 VSS VDD VDD sky130_fd_sc_hd__fill_1
* cell instance sky130_fd_sc_hd__fill_1_570 r0 *1 0,0
Xsky130_fd_sc_hd__fill_1_570 VSS VDD VDD sky130_fd_sc_hd__fill_1
* cell instance sky130_fd_sc_hd__fill_1_571 r0 *1 0,0
Xsky130_fd_sc_hd__fill_1_571 VSS VDD VDD sky130_fd_sc_hd__fill_1
* cell instance sky130_fd_sc_hd__fill_1_572 r0 *1 0,0
Xsky130_fd_sc_hd__fill_1_572 VSS VDD VDD sky130_fd_sc_hd__fill_1
* cell instance sky130_fd_sc_hd__fill_1_573 r0 *1 0,0
Xsky130_fd_sc_hd__fill_1_573 VSS VDD VDD sky130_fd_sc_hd__fill_1
* cell instance sky130_fd_sc_hd__fill_1_574 r0 *1 0,0
Xsky130_fd_sc_hd__fill_1_574 VSS VDD VDD sky130_fd_sc_hd__fill_1
* cell instance sky130_fd_sc_hd__fill_1_575 r0 *1 0,0
Xsky130_fd_sc_hd__fill_1_575 VSS VDD VDD sky130_fd_sc_hd__fill_1
* cell instance sky130_fd_sc_hd__fill_1_576 r0 *1 0,0
Xsky130_fd_sc_hd__fill_1_576 VSS VDD VDD sky130_fd_sc_hd__fill_1
* cell instance sky130_fd_sc_hd__fill_1_577 r0 *1 0,0
Xsky130_fd_sc_hd__fill_1_577 VSS VDD VDD sky130_fd_sc_hd__fill_1
* cell instance sky130_fd_sc_hd__fill_1_578 r0 *1 0,0
Xsky130_fd_sc_hd__fill_1_578 VSS VDD VDD sky130_fd_sc_hd__fill_1
* cell instance sky130_fd_sc_hd__fill_1_579 r0 *1 0,0
Xsky130_fd_sc_hd__fill_1_579 VSS VDD VDD sky130_fd_sc_hd__fill_1
* cell instance sky130_fd_sc_hd__fill_1_580 r0 *1 0,0
Xsky130_fd_sc_hd__fill_1_580 VSS VDD VDD sky130_fd_sc_hd__fill_1
* cell instance sky130_fd_sc_hd__fill_1_581 r0 *1 0,0
Xsky130_fd_sc_hd__fill_1_581 VSS VDD VDD sky130_fd_sc_hd__fill_1
* cell instance sky130_fd_sc_hd__fill_1_582 r0 *1 0,0
Xsky130_fd_sc_hd__fill_1_582 VSS VDD VDD sky130_fd_sc_hd__fill_1
* cell instance sky130_fd_sc_hd__fill_1_583 r0 *1 0,0
Xsky130_fd_sc_hd__fill_1_583 VSS VDD VDD sky130_fd_sc_hd__fill_1
* cell instance sky130_fd_sc_hd__fill_1_584 r0 *1 0,0
Xsky130_fd_sc_hd__fill_1_584 VSS VDD VDD sky130_fd_sc_hd__fill_1
* cell instance sky130_fd_sc_hd__fill_1_585 r0 *1 0,0
Xsky130_fd_sc_hd__fill_1_585 VSS VDD VDD sky130_fd_sc_hd__fill_1
* cell instance sky130_fd_sc_hd__fill_1_586 r0 *1 0,0
Xsky130_fd_sc_hd__fill_1_586 VSS VDD VDD sky130_fd_sc_hd__fill_1
* cell instance sky130_fd_sc_hd__fill_1_587 r0 *1 0,0
Xsky130_fd_sc_hd__fill_1_587 VSS VDD VDD sky130_fd_sc_hd__fill_1
* cell instance sky130_fd_sc_hd__fill_1_588 r0 *1 0,0
Xsky130_fd_sc_hd__fill_1_588 VSS VDD VDD sky130_fd_sc_hd__fill_1
* cell instance sky130_fd_sc_hd__fill_1_589 r0 *1 0,0
Xsky130_fd_sc_hd__fill_1_589 VSS VDD VDD sky130_fd_sc_hd__fill_1
* cell instance sky130_fd_sc_hd__fill_1_590 r0 *1 0,0
Xsky130_fd_sc_hd__fill_1_590 VSS VDD VDD sky130_fd_sc_hd__fill_1
* cell instance sky130_fd_sc_hd__fill_1_591 r0 *1 0,0
Xsky130_fd_sc_hd__fill_1_591 VSS VDD VDD sky130_fd_sc_hd__fill_1
* cell instance sky130_fd_sc_hd__fill_1_592 r0 *1 0,0
Xsky130_fd_sc_hd__fill_1_592 VSS VDD VDD sky130_fd_sc_hd__fill_1
* cell instance sky130_fd_sc_hd__fill_1_593 r0 *1 0,0
Xsky130_fd_sc_hd__fill_1_593 VSS VDD VDD sky130_fd_sc_hd__fill_1
* cell instance sky130_fd_sc_hd__fill_1_594 r0 *1 0,0
Xsky130_fd_sc_hd__fill_1_594 VSS VDD VDD sky130_fd_sc_hd__fill_1
* cell instance sky130_fd_sc_hd__fill_1_595 r0 *1 0,0
Xsky130_fd_sc_hd__fill_1_595 VSS VDD VDD sky130_fd_sc_hd__fill_1
* cell instance sky130_fd_sc_hd__fill_1_596 r0 *1 0,0
Xsky130_fd_sc_hd__fill_1_596 VSS VDD VDD sky130_fd_sc_hd__fill_1
* cell instance sky130_fd_sc_hd__fill_1_597 r0 *1 0,0
Xsky130_fd_sc_hd__fill_1_597 VSS VDD VDD sky130_fd_sc_hd__fill_1
* cell instance sky130_fd_sc_hd__fill_1_598 r0 *1 0,0
Xsky130_fd_sc_hd__fill_1_598 VSS VDD VDD sky130_fd_sc_hd__fill_1
* cell instance sky130_fd_sc_hd__fill_1_599 r0 *1 0,0
Xsky130_fd_sc_hd__fill_1_599 VSS VDD VDD sky130_fd_sc_hd__fill_1
* cell instance sky130_fd_sc_hd__fill_1_600 r0 *1 0,0
Xsky130_fd_sc_hd__fill_1_600 VSS VDD VDD sky130_fd_sc_hd__fill_1
* cell instance sky130_fd_sc_hd__fill_1_601 r0 *1 0,0
Xsky130_fd_sc_hd__fill_1_601 VSS VDD VDD sky130_fd_sc_hd__fill_1
* cell instance sky130_fd_sc_hd__fill_1_602 r0 *1 0,0
Xsky130_fd_sc_hd__fill_1_602 VSS VDD VDD sky130_fd_sc_hd__fill_1
* cell instance sky130_fd_sc_hd__fill_1_603 r0 *1 0,0
Xsky130_fd_sc_hd__fill_1_603 VSS VDD VDD sky130_fd_sc_hd__fill_1
* cell instance sky130_fd_sc_hd__fill_1_604 r0 *1 0,0
Xsky130_fd_sc_hd__fill_1_604 VSS VDD VDD sky130_fd_sc_hd__fill_1
* cell instance sky130_fd_sc_hd__fill_1_605 r0 *1 0,0
Xsky130_fd_sc_hd__fill_1_605 VSS VDD VDD sky130_fd_sc_hd__fill_1
* cell instance sky130_fd_sc_hd__fill_1_606 r0 *1 0,0
Xsky130_fd_sc_hd__fill_1_606 VSS VDD VDD sky130_fd_sc_hd__fill_1
* cell instance sky130_fd_sc_hd__fill_1_607 r0 *1 0,0
Xsky130_fd_sc_hd__fill_1_607 VSS VDD VDD sky130_fd_sc_hd__fill_1
* cell instance sky130_fd_sc_hd__fill_1_608 r0 *1 0,0
Xsky130_fd_sc_hd__fill_1_608 VSS VDD VDD sky130_fd_sc_hd__fill_1
* cell instance sky130_fd_sc_hd__fill_1_609 r0 *1 0,0
Xsky130_fd_sc_hd__fill_1_609 VSS VDD VDD sky130_fd_sc_hd__fill_1
* cell instance sky130_fd_sc_hd__fill_1_610 r0 *1 0,0
Xsky130_fd_sc_hd__fill_1_610 VSS VDD VDD sky130_fd_sc_hd__fill_1
* cell instance sky130_fd_sc_hd__fill_1_611 r0 *1 0,0
Xsky130_fd_sc_hd__fill_1_611 VSS VDD VDD sky130_fd_sc_hd__fill_1
* cell instance sky130_fd_sc_hd__fill_1_612 r0 *1 0,0
Xsky130_fd_sc_hd__fill_1_612 VSS VDD VDD sky130_fd_sc_hd__fill_1
* cell instance sky130_fd_sc_hd__fill_1_613 r0 *1 0,0
Xsky130_fd_sc_hd__fill_1_613 VSS VDD VDD sky130_fd_sc_hd__fill_1
* cell instance sky130_fd_sc_hd__fill_1_614 r0 *1 0,0
Xsky130_fd_sc_hd__fill_1_614 VSS VDD VDD sky130_fd_sc_hd__fill_1
* cell instance sky130_fd_sc_hd__fill_1_615 r0 *1 0,0
Xsky130_fd_sc_hd__fill_1_615 VSS VDD VDD sky130_fd_sc_hd__fill_1
* cell instance sky130_fd_sc_hd__fill_1_616 r0 *1 0,0
Xsky130_fd_sc_hd__fill_1_616 VSS VDD VDD sky130_fd_sc_hd__fill_1
* cell instance sky130_fd_sc_hd__fill_1_617 r0 *1 0,0
Xsky130_fd_sc_hd__fill_1_617 VSS VDD VDD sky130_fd_sc_hd__fill_1
* cell instance sky130_fd_sc_hd__fill_1_618 r0 *1 0,0
Xsky130_fd_sc_hd__fill_1_618 VSS VDD VDD sky130_fd_sc_hd__fill_1
* cell instance sky130_fd_sc_hd__fill_1_619 r0 *1 0,0
Xsky130_fd_sc_hd__fill_1_619 VSS VDD VDD sky130_fd_sc_hd__fill_1
* cell instance sky130_fd_sc_hd__fill_1_620 r0 *1 0,0
Xsky130_fd_sc_hd__fill_1_620 VSS VDD VDD sky130_fd_sc_hd__fill_1
* cell instance sky130_fd_sc_hd__fill_1_621 r0 *1 0,0
Xsky130_fd_sc_hd__fill_1_621 VSS VDD VDD sky130_fd_sc_hd__fill_1
* cell instance sky130_fd_sc_hd__fill_1_622 r0 *1 0,0
Xsky130_fd_sc_hd__fill_1_622 VSS VDD VDD sky130_fd_sc_hd__fill_1
* cell instance sky130_fd_sc_hd__fill_1_623 r0 *1 0,0
Xsky130_fd_sc_hd__fill_1_623 VSS VDD VDD sky130_fd_sc_hd__fill_1
* cell instance sky130_fd_sc_hd__fill_1_624 r0 *1 0,0
Xsky130_fd_sc_hd__fill_1_624 VSS VDD VDD sky130_fd_sc_hd__fill_1
* cell instance sky130_fd_sc_hd__fill_1_625 r0 *1 0,0
Xsky130_fd_sc_hd__fill_1_625 VSS VDD VDD sky130_fd_sc_hd__fill_1
* cell instance sky130_fd_sc_hd__fill_1_626 r0 *1 0,0
Xsky130_fd_sc_hd__fill_1_626 VSS VDD VDD sky130_fd_sc_hd__fill_1
* cell instance sky130_fd_sc_hd__fill_1_627 r0 *1 0,0
Xsky130_fd_sc_hd__fill_1_627 VSS VDD VDD sky130_fd_sc_hd__fill_1
* cell instance sky130_fd_sc_hd__fill_1_628 r0 *1 0,0
Xsky130_fd_sc_hd__fill_1_628 VSS VDD VDD sky130_fd_sc_hd__fill_1
* cell instance sky130_fd_sc_hd__fill_1_629 r0 *1 0,0
Xsky130_fd_sc_hd__fill_1_629 VSS VDD VDD sky130_fd_sc_hd__fill_1
* cell instance sky130_fd_sc_hd__fill_1_630 r0 *1 0,0
Xsky130_fd_sc_hd__fill_1_630 VSS VDD VDD sky130_fd_sc_hd__fill_1
* cell instance sky130_fd_sc_hd__fill_1_631 r0 *1 0,0
Xsky130_fd_sc_hd__fill_1_631 VSS VDD VDD sky130_fd_sc_hd__fill_1
* cell instance sky130_fd_sc_hd__fill_1_632 r0 *1 0,0
Xsky130_fd_sc_hd__fill_1_632 VSS VDD VDD sky130_fd_sc_hd__fill_1
* cell instance sky130_fd_sc_hd__fill_1_633 r0 *1 0,0
Xsky130_fd_sc_hd__fill_1_633 VSS VDD VDD sky130_fd_sc_hd__fill_1
* cell instance sky130_fd_sc_hd__fill_1_634 r0 *1 0,0
Xsky130_fd_sc_hd__fill_1_634 VSS VDD VDD sky130_fd_sc_hd__fill_1
* cell instance sky130_fd_sc_hd__fill_1_635 r0 *1 0,0
Xsky130_fd_sc_hd__fill_1_635 VSS VDD VDD sky130_fd_sc_hd__fill_1
* cell instance sky130_fd_sc_hd__fill_1_636 r0 *1 0,0
Xsky130_fd_sc_hd__fill_1_636 VSS VDD VDD sky130_fd_sc_hd__fill_1
* cell instance sky130_fd_sc_hd__fill_1_637 r0 *1 0,0
Xsky130_fd_sc_hd__fill_1_637 VSS VDD VDD sky130_fd_sc_hd__fill_1
* cell instance sky130_fd_sc_hd__fill_1_638 r0 *1 0,0
Xsky130_fd_sc_hd__fill_1_638 VSS VDD VDD sky130_fd_sc_hd__fill_1
* cell instance sky130_fd_sc_hd__fill_1_639 r0 *1 0,0
Xsky130_fd_sc_hd__fill_1_639 VSS VDD VDD sky130_fd_sc_hd__fill_1
* cell instance sky130_fd_sc_hd__fill_1_640 r0 *1 0,0
Xsky130_fd_sc_hd__fill_1_640 VSS VDD VDD sky130_fd_sc_hd__fill_1
* cell instance sky130_fd_sc_hd__fill_1_641 r0 *1 0,0
Xsky130_fd_sc_hd__fill_1_641 VSS VDD VDD sky130_fd_sc_hd__fill_1
* cell instance sky130_fd_sc_hd__fill_1_642 r0 *1 0,0
Xsky130_fd_sc_hd__fill_1_642 VSS VDD VDD sky130_fd_sc_hd__fill_1
* cell instance sky130_fd_sc_hd__fill_1_643 r0 *1 0,0
Xsky130_fd_sc_hd__fill_1_643 VSS VDD VDD sky130_fd_sc_hd__fill_1
* cell instance sky130_fd_sc_hd__fill_1_644 r0 *1 0,0
Xsky130_fd_sc_hd__fill_1_644 VSS VDD VDD sky130_fd_sc_hd__fill_1
* cell instance sky130_fd_sc_hd__fill_1_645 r0 *1 0,0
Xsky130_fd_sc_hd__fill_1_645 VSS VDD VDD sky130_fd_sc_hd__fill_1
* cell instance sky130_fd_sc_hd__fill_1_646 r0 *1 0,0
Xsky130_fd_sc_hd__fill_1_646 VSS VDD VDD sky130_fd_sc_hd__fill_1
* cell instance sky130_fd_sc_hd__fill_1_647 r0 *1 0,0
Xsky130_fd_sc_hd__fill_1_647 VSS VDD VDD sky130_fd_sc_hd__fill_1
* cell instance sky130_fd_sc_hd__fill_1_648 r0 *1 0,0
Xsky130_fd_sc_hd__fill_1_648 VSS VDD VDD sky130_fd_sc_hd__fill_1
* cell instance sky130_fd_sc_hd__fill_1_649 r0 *1 0,0
Xsky130_fd_sc_hd__fill_1_649 VSS VDD VDD sky130_fd_sc_hd__fill_1
* cell instance sky130_fd_sc_hd__fill_1_650 r0 *1 0,0
Xsky130_fd_sc_hd__fill_1_650 VSS VDD VDD sky130_fd_sc_hd__fill_1
* cell instance sky130_fd_sc_hd__fill_1_651 r0 *1 0,0
Xsky130_fd_sc_hd__fill_1_651 VSS VDD VDD sky130_fd_sc_hd__fill_1
* cell instance sky130_fd_sc_hd__fill_1_652 r0 *1 0,0
Xsky130_fd_sc_hd__fill_1_652 VSS VDD VDD sky130_fd_sc_hd__fill_1
* cell instance sky130_fd_sc_hd__fill_1_653 r0 *1 0,0
Xsky130_fd_sc_hd__fill_1_653 VSS VDD VDD sky130_fd_sc_hd__fill_1
* cell instance sky130_fd_sc_hd__fill_1_654 r0 *1 0,0
Xsky130_fd_sc_hd__fill_1_654 VSS VDD VDD sky130_fd_sc_hd__fill_1
* cell instance sky130_fd_sc_hd__fill_1_655 r0 *1 0,0
Xsky130_fd_sc_hd__fill_1_655 VSS VDD VDD sky130_fd_sc_hd__fill_1
* cell instance sky130_fd_sc_hd__fill_1_656 r0 *1 0,0
Xsky130_fd_sc_hd__fill_1_656 VSS VDD VDD sky130_fd_sc_hd__fill_1
* cell instance sky130_fd_sc_hd__fill_1_657 r0 *1 0,0
Xsky130_fd_sc_hd__fill_1_657 VSS VDD VDD sky130_fd_sc_hd__fill_1
* cell instance sky130_fd_sc_hd__fill_1_658 r0 *1 0,0
Xsky130_fd_sc_hd__fill_1_658 VSS VDD VDD sky130_fd_sc_hd__fill_1
* cell instance sky130_fd_sc_hd__fill_1_659 r0 *1 0,0
Xsky130_fd_sc_hd__fill_1_659 VSS VDD VDD sky130_fd_sc_hd__fill_1
* cell instance sky130_fd_sc_hd__fill_1_660 r0 *1 0,0
Xsky130_fd_sc_hd__fill_1_660 VSS VDD VDD sky130_fd_sc_hd__fill_1
* cell instance sky130_fd_sc_hd__fill_1_661 r0 *1 0,0
Xsky130_fd_sc_hd__fill_1_661 VSS VDD VDD sky130_fd_sc_hd__fill_1
* cell instance sky130_fd_sc_hd__fill_1_662 r0 *1 0,0
Xsky130_fd_sc_hd__fill_1_662 VSS VDD VDD sky130_fd_sc_hd__fill_1
* cell instance sky130_fd_sc_hd__fill_1_663 r0 *1 0,0
Xsky130_fd_sc_hd__fill_1_663 VSS VDD VDD sky130_fd_sc_hd__fill_1
* cell instance sky130_fd_sc_hd__fill_1_664 r0 *1 0,0
Xsky130_fd_sc_hd__fill_1_664 VSS VDD VDD sky130_fd_sc_hd__fill_1
* cell instance sky130_fd_sc_hd__fill_1_665 r0 *1 0,0
Xsky130_fd_sc_hd__fill_1_665 VSS VDD VDD sky130_fd_sc_hd__fill_1
* cell instance sky130_fd_sc_hd__fill_1_666 r0 *1 0,0
Xsky130_fd_sc_hd__fill_1_666 VSS VDD VDD sky130_fd_sc_hd__fill_1
* cell instance sky130_fd_sc_hd__fill_1_667 r0 *1 0,0
Xsky130_fd_sc_hd__fill_1_667 VSS VDD VDD sky130_fd_sc_hd__fill_1
* cell instance sky130_fd_sc_hd__fill_1_668 r0 *1 0,0
Xsky130_fd_sc_hd__fill_1_668 VSS VDD VDD sky130_fd_sc_hd__fill_1
* cell instance sky130_fd_sc_hd__fill_1_669 r0 *1 0,0
Xsky130_fd_sc_hd__fill_1_669 VSS VDD VDD sky130_fd_sc_hd__fill_1
* cell instance sky130_fd_sc_hd__fill_1_670 r0 *1 0,0
Xsky130_fd_sc_hd__fill_1_670 VSS VDD VDD sky130_fd_sc_hd__fill_1
* cell instance sky130_fd_sc_hd__fill_1_671 r0 *1 0,0
Xsky130_fd_sc_hd__fill_1_671 VSS VDD VDD sky130_fd_sc_hd__fill_1
* cell instance sky130_fd_sc_hd__fill_1_672 r0 *1 0,0
Xsky130_fd_sc_hd__fill_1_672 VSS VDD VDD sky130_fd_sc_hd__fill_1
* cell instance sky130_fd_sc_hd__fill_1_673 r0 *1 0,0
Xsky130_fd_sc_hd__fill_1_673 VSS VDD VDD sky130_fd_sc_hd__fill_1
* cell instance sky130_fd_sc_hd__fill_1_674 r0 *1 0,0
Xsky130_fd_sc_hd__fill_1_674 VSS VDD VDD sky130_fd_sc_hd__fill_1
* cell instance sky130_fd_sc_hd__fill_1_675 r0 *1 0,0
Xsky130_fd_sc_hd__fill_1_675 VSS VDD VDD sky130_fd_sc_hd__fill_1
* cell instance sky130_fd_sc_hd__fill_1_676 r0 *1 0,0
Xsky130_fd_sc_hd__fill_1_676 VSS VDD VDD sky130_fd_sc_hd__fill_1
* cell instance sky130_fd_sc_hd__fill_1_677 r0 *1 0,0
Xsky130_fd_sc_hd__fill_1_677 VSS VDD VDD sky130_fd_sc_hd__fill_1
* cell instance sky130_fd_sc_hd__fill_1_678 r0 *1 0,0
Xsky130_fd_sc_hd__fill_1_678 VSS VDD VDD sky130_fd_sc_hd__fill_1
* cell instance sky130_fd_sc_hd__fill_1_679 r0 *1 0,0
Xsky130_fd_sc_hd__fill_1_679 VSS VDD VDD sky130_fd_sc_hd__fill_1
* cell instance sky130_fd_sc_hd__fill_1_680 r0 *1 0,0
Xsky130_fd_sc_hd__fill_1_680 VSS VDD VDD sky130_fd_sc_hd__fill_1
* cell instance sky130_fd_sc_hd__fill_1_681 r0 *1 0,0
Xsky130_fd_sc_hd__fill_1_681 VSS VDD VDD sky130_fd_sc_hd__fill_1
* cell instance sky130_fd_sc_hd__fill_1_682 r0 *1 0,0
Xsky130_fd_sc_hd__fill_1_682 VSS VDD VDD sky130_fd_sc_hd__fill_1
* cell instance sky130_fd_sc_hd__fill_1_683 r0 *1 0,0
Xsky130_fd_sc_hd__fill_1_683 VSS VDD VDD sky130_fd_sc_hd__fill_1
* cell instance sky130_fd_sc_hd__fill_1_684 r0 *1 0,0
Xsky130_fd_sc_hd__fill_1_684 VSS VDD VDD sky130_fd_sc_hd__fill_1
* cell instance sky130_fd_sc_hd__fill_1_685 r0 *1 0,0
Xsky130_fd_sc_hd__fill_1_685 VSS VDD VDD sky130_fd_sc_hd__fill_1
* cell instance sky130_fd_sc_hd__fill_1_686 r0 *1 0,0
Xsky130_fd_sc_hd__fill_1_686 VSS VDD VDD sky130_fd_sc_hd__fill_1
* cell instance sky130_fd_sc_hd__fill_1_687 r0 *1 0,0
Xsky130_fd_sc_hd__fill_1_687 VSS VDD VDD sky130_fd_sc_hd__fill_1
* cell instance sky130_fd_sc_hd__fill_1_688 r0 *1 0,0
Xsky130_fd_sc_hd__fill_1_688 VSS VDD VDD sky130_fd_sc_hd__fill_1
* cell instance sky130_fd_sc_hd__fill_1_689 r0 *1 0,0
Xsky130_fd_sc_hd__fill_1_689 VSS VDD VDD sky130_fd_sc_hd__fill_1
* cell instance sky130_fd_sc_hd__fill_1_690 r0 *1 0,0
Xsky130_fd_sc_hd__fill_1_690 VSS VDD VDD sky130_fd_sc_hd__fill_1
* cell instance sky130_fd_sc_hd__fill_1_691 r0 *1 0,0
Xsky130_fd_sc_hd__fill_1_691 VSS VDD VDD sky130_fd_sc_hd__fill_1
* cell instance sky130_fd_sc_hd__fill_1_692 r0 *1 0,0
Xsky130_fd_sc_hd__fill_1_692 VSS VDD VDD sky130_fd_sc_hd__fill_1
* cell instance sky130_fd_sc_hd__fill_1_693 r0 *1 0,0
Xsky130_fd_sc_hd__fill_1_693 VSS VDD VDD sky130_fd_sc_hd__fill_1
* cell instance sky130_fd_sc_hd__fill_1_694 r0 *1 0,0
Xsky130_fd_sc_hd__fill_1_694 VSS VDD VDD sky130_fd_sc_hd__fill_1
* cell instance sky130_fd_sc_hd__fill_1_695 r0 *1 0,0
Xsky130_fd_sc_hd__fill_1_695 VSS VDD VDD sky130_fd_sc_hd__fill_1
* cell instance sky130_fd_sc_hd__fill_1_696 r0 *1 0,0
Xsky130_fd_sc_hd__fill_1_696 VSS VDD VDD sky130_fd_sc_hd__fill_1
* cell instance sky130_fd_sc_hd__fill_1_697 r0 *1 0,0
Xsky130_fd_sc_hd__fill_1_697 VSS VDD VDD sky130_fd_sc_hd__fill_1
* cell instance sky130_fd_sc_hd__fill_1_698 r0 *1 0,0
Xsky130_fd_sc_hd__fill_1_698 VSS VDD VDD sky130_fd_sc_hd__fill_1
* cell instance sky130_fd_sc_hd__fill_1_699 r0 *1 0,0
Xsky130_fd_sc_hd__fill_1_699 VSS VDD VDD sky130_fd_sc_hd__fill_1
* cell instance sky130_fd_sc_hd__fill_1_700 r0 *1 0,0
Xsky130_fd_sc_hd__fill_1_700 VSS VDD VDD sky130_fd_sc_hd__fill_1
* cell instance sky130_fd_sc_hd__fill_1_701 r0 *1 0,0
Xsky130_fd_sc_hd__fill_1_701 VSS VDD VDD sky130_fd_sc_hd__fill_1
* cell instance sky130_fd_sc_hd__fill_1_702 r0 *1 0,0
Xsky130_fd_sc_hd__fill_1_702 VSS VDD VDD sky130_fd_sc_hd__fill_1
* cell instance sky130_fd_sc_hd__fill_1_703 r0 *1 0,0
Xsky130_fd_sc_hd__fill_1_703 VSS VDD VDD sky130_fd_sc_hd__fill_1
* cell instance sky130_fd_sc_hd__fill_1_704 r0 *1 0,0
Xsky130_fd_sc_hd__fill_1_704 VSS VDD VDD sky130_fd_sc_hd__fill_1
* cell instance sky130_fd_sc_hd__fill_1_705 r0 *1 0,0
Xsky130_fd_sc_hd__fill_1_705 VSS VDD VDD sky130_fd_sc_hd__fill_1
* cell instance sky130_fd_sc_hd__fill_1_706 r0 *1 0,0
Xsky130_fd_sc_hd__fill_1_706 VSS VDD VDD sky130_fd_sc_hd__fill_1
* cell instance sky130_fd_sc_hd__fill_1_707 r0 *1 0,0
Xsky130_fd_sc_hd__fill_1_707 VSS VDD VDD sky130_fd_sc_hd__fill_1
* cell instance sky130_fd_sc_hd__fill_1_708 r0 *1 0,0
Xsky130_fd_sc_hd__fill_1_708 VSS VDD VDD sky130_fd_sc_hd__fill_1
* cell instance sky130_fd_sc_hd__fill_1_709 r0 *1 0,0
Xsky130_fd_sc_hd__fill_1_709 VSS VDD VDD sky130_fd_sc_hd__fill_1
* cell instance sky130_fd_sc_hd__fill_1_710 r0 *1 0,0
Xsky130_fd_sc_hd__fill_1_710 VSS VDD VDD sky130_fd_sc_hd__fill_1
* cell instance sky130_fd_sc_hd__fill_1_711 r0 *1 0,0
Xsky130_fd_sc_hd__fill_1_711 VSS VDD VDD sky130_fd_sc_hd__fill_1
* cell instance sky130_fd_sc_hd__fill_1_712 r0 *1 0,0
Xsky130_fd_sc_hd__fill_1_712 VSS VDD VDD sky130_fd_sc_hd__fill_1
* cell instance sky130_fd_sc_hd__fill_1_713 r0 *1 0,0
Xsky130_fd_sc_hd__fill_1_713 VSS VDD VDD sky130_fd_sc_hd__fill_1
* cell instance sky130_fd_sc_hd__fill_1_714 r0 *1 0,0
Xsky130_fd_sc_hd__fill_1_714 VSS VDD VDD sky130_fd_sc_hd__fill_1
* cell instance sky130_fd_sc_hd__fill_1_715 r0 *1 0,0
Xsky130_fd_sc_hd__fill_1_715 VSS VDD VDD sky130_fd_sc_hd__fill_1
* cell instance sky130_fd_sc_hd__fill_1_716 r0 *1 0,0
Xsky130_fd_sc_hd__fill_1_716 VSS VDD VDD sky130_fd_sc_hd__fill_1
* cell instance sky130_fd_sc_hd__fill_1_717 r0 *1 0,0
Xsky130_fd_sc_hd__fill_1_717 VSS VDD VDD sky130_fd_sc_hd__fill_1
* cell instance sky130_fd_sc_hd__fill_1_718 r0 *1 0,0
Xsky130_fd_sc_hd__fill_1_718 VSS VDD VDD sky130_fd_sc_hd__fill_1
* cell instance sky130_fd_sc_hd__fill_1_719 r0 *1 0,0
Xsky130_fd_sc_hd__fill_1_719 VSS VDD VDD sky130_fd_sc_hd__fill_1
* cell instance sky130_fd_sc_hd__fill_1_720 r0 *1 0,0
Xsky130_fd_sc_hd__fill_1_720 VSS VDD VDD sky130_fd_sc_hd__fill_1
* cell instance sky130_fd_sc_hd__fill_1_721 r0 *1 0,0
Xsky130_fd_sc_hd__fill_1_721 VSS VDD VDD sky130_fd_sc_hd__fill_1
* cell instance sky130_fd_sc_hd__fill_1_722 r0 *1 0,0
Xsky130_fd_sc_hd__fill_1_722 VSS VDD VDD sky130_fd_sc_hd__fill_1
* cell instance sky130_fd_sc_hd__fill_1_723 r0 *1 0,0
Xsky130_fd_sc_hd__fill_1_723 VSS VDD VDD sky130_fd_sc_hd__fill_1
* cell instance sky130_fd_sc_hd__fill_1_724 r0 *1 0,0
Xsky130_fd_sc_hd__fill_1_724 VSS VDD VDD sky130_fd_sc_hd__fill_1
* cell instance sky130_fd_sc_hd__fill_1_725 r0 *1 0,0
Xsky130_fd_sc_hd__fill_1_725 VSS VDD VDD sky130_fd_sc_hd__fill_1
* cell instance sky130_fd_sc_hd__fill_1_726 r0 *1 0,0
Xsky130_fd_sc_hd__fill_1_726 VSS VDD VDD sky130_fd_sc_hd__fill_1
* cell instance sky130_fd_sc_hd__fill_1_727 r0 *1 0,0
Xsky130_fd_sc_hd__fill_1_727 VSS VDD VDD sky130_fd_sc_hd__fill_1
* cell instance sky130_fd_sc_hd__fill_1_728 r0 *1 0,0
Xsky130_fd_sc_hd__fill_1_728 VSS VDD VDD sky130_fd_sc_hd__fill_1
* cell instance sky130_fd_sc_hd__fill_1_729 r0 *1 0,0
Xsky130_fd_sc_hd__fill_1_729 VSS VDD VDD sky130_fd_sc_hd__fill_1
* cell instance sky130_fd_sc_hd__fill_1_730 r0 *1 0,0
Xsky130_fd_sc_hd__fill_1_730 VSS VDD VDD sky130_fd_sc_hd__fill_1
* cell instance sky130_fd_sc_hd__fill_1_731 r0 *1 0,0
Xsky130_fd_sc_hd__fill_1_731 VSS VDD VDD sky130_fd_sc_hd__fill_1
* cell instance sky130_fd_sc_hd__fill_1_732 r0 *1 0,0
Xsky130_fd_sc_hd__fill_1_732 VSS VDD VDD sky130_fd_sc_hd__fill_1
* cell instance sky130_fd_sc_hd__fill_1_733 r0 *1 0,0
Xsky130_fd_sc_hd__fill_1_733 VSS VDD VDD sky130_fd_sc_hd__fill_1
* cell instance sky130_fd_sc_hd__fill_1_734 r0 *1 0,0
Xsky130_fd_sc_hd__fill_1_734 VSS VDD VDD sky130_fd_sc_hd__fill_1
* cell instance sky130_fd_sc_hd__fill_1_735 r0 *1 0,0
Xsky130_fd_sc_hd__fill_1_735 VSS VDD VDD sky130_fd_sc_hd__fill_1
* cell instance sky130_fd_sc_hd__fill_1_736 r0 *1 0,0
Xsky130_fd_sc_hd__fill_1_736 VSS VDD VDD sky130_fd_sc_hd__fill_1
* cell instance sky130_fd_sc_hd__fill_1_737 r0 *1 0,0
Xsky130_fd_sc_hd__fill_1_737 VSS VDD VDD sky130_fd_sc_hd__fill_1
* cell instance sky130_fd_sc_hd__fill_1_738 r0 *1 0,0
Xsky130_fd_sc_hd__fill_1_738 VSS VDD VDD sky130_fd_sc_hd__fill_1
* cell instance sky130_fd_sc_hd__fill_1_739 r0 *1 0,0
Xsky130_fd_sc_hd__fill_1_739 VSS VDD VDD sky130_fd_sc_hd__fill_1
* cell instance sky130_fd_sc_hd__fill_1_740 r0 *1 0,0
Xsky130_fd_sc_hd__fill_1_740 VSS VDD VDD sky130_fd_sc_hd__fill_1
* cell instance sky130_fd_sc_hd__fill_1_741 r0 *1 0,0
Xsky130_fd_sc_hd__fill_1_741 VSS VDD VDD sky130_fd_sc_hd__fill_1
* cell instance sky130_fd_sc_hd__fill_1_742 r0 *1 0,0
Xsky130_fd_sc_hd__fill_1_742 VSS VDD VDD sky130_fd_sc_hd__fill_1
* cell instance sky130_fd_sc_hd__fill_1_743 r0 *1 0,0
Xsky130_fd_sc_hd__fill_1_743 VSS VDD VDD sky130_fd_sc_hd__fill_1
* cell instance sky130_fd_sc_hd__fill_1_744 r0 *1 0,0
Xsky130_fd_sc_hd__fill_1_744 VSS VDD VDD sky130_fd_sc_hd__fill_1
* cell instance sky130_fd_sc_hd__fill_1_745 r0 *1 0,0
Xsky130_fd_sc_hd__fill_1_745 VSS VDD VDD sky130_fd_sc_hd__fill_1
* cell instance sky130_fd_sc_hd__fill_1_746 r0 *1 0,0
Xsky130_fd_sc_hd__fill_1_746 VSS VDD VDD sky130_fd_sc_hd__fill_1
* cell instance sky130_fd_sc_hd__fill_1_747 r0 *1 0,0
Xsky130_fd_sc_hd__fill_1_747 VSS VDD VDD sky130_fd_sc_hd__fill_1
* cell instance sky130_fd_sc_hd__fill_1_748 r0 *1 0,0
Xsky130_fd_sc_hd__fill_1_748 VSS VDD VDD sky130_fd_sc_hd__fill_1
* cell instance sky130_fd_sc_hd__fill_1_749 r0 *1 0,0
Xsky130_fd_sc_hd__fill_1_749 VSS VDD VDD sky130_fd_sc_hd__fill_1
* cell instance sky130_fd_sc_hd__fill_1_750 r0 *1 0,0
Xsky130_fd_sc_hd__fill_1_750 VSS VDD VDD sky130_fd_sc_hd__fill_1
* cell instance sky130_fd_sc_hd__fill_1_751 r0 *1 0,0
Xsky130_fd_sc_hd__fill_1_751 VSS VDD VDD sky130_fd_sc_hd__fill_1
* cell instance sky130_fd_sc_hd__fill_1_752 r0 *1 0,0
Xsky130_fd_sc_hd__fill_1_752 VSS VDD VDD sky130_fd_sc_hd__fill_1
* cell instance sky130_fd_sc_hd__fill_1_753 r0 *1 0,0
Xsky130_fd_sc_hd__fill_1_753 VSS VDD VDD sky130_fd_sc_hd__fill_1
* cell instance sky130_fd_sc_hd__fill_1_754 r0 *1 0,0
Xsky130_fd_sc_hd__fill_1_754 VSS VDD VDD sky130_fd_sc_hd__fill_1
* cell instance sky130_fd_sc_hd__fill_1_755 r0 *1 0,0
Xsky130_fd_sc_hd__fill_1_755 VSS VDD VDD sky130_fd_sc_hd__fill_1
* cell instance sky130_fd_sc_hd__fill_1_756 r0 *1 0,0
Xsky130_fd_sc_hd__fill_1_756 VSS VDD VDD sky130_fd_sc_hd__fill_1
* cell instance sky130_fd_sc_hd__fill_1_757 r0 *1 0,0
Xsky130_fd_sc_hd__fill_1_757 VSS VDD VDD sky130_fd_sc_hd__fill_1
* cell instance sky130_fd_sc_hd__fill_1_758 r0 *1 0,0
Xsky130_fd_sc_hd__fill_1_758 VSS VDD VDD sky130_fd_sc_hd__fill_1
* cell instance sky130_fd_sc_hd__fill_1_759 r0 *1 0,0
Xsky130_fd_sc_hd__fill_1_759 VSS VDD VDD sky130_fd_sc_hd__fill_1
* cell instance sky130_fd_sc_hd__fill_1_760 r0 *1 0,0
Xsky130_fd_sc_hd__fill_1_760 VSS VDD VDD sky130_fd_sc_hd__fill_1
* cell instance sky130_fd_sc_hd__fill_1_761 r0 *1 0,0
Xsky130_fd_sc_hd__fill_1_761 VSS VDD VDD sky130_fd_sc_hd__fill_1
* cell instance sky130_fd_sc_hd__fill_1_762 r0 *1 0,0
Xsky130_fd_sc_hd__fill_1_762 VSS VDD VDD sky130_fd_sc_hd__fill_1
* cell instance sky130_fd_sc_hd__fill_1_763 r0 *1 0,0
Xsky130_fd_sc_hd__fill_1_763 VSS VDD VDD sky130_fd_sc_hd__fill_1
* cell instance sky130_fd_sc_hd__fill_1_764 r0 *1 0,0
Xsky130_fd_sc_hd__fill_1_764 VSS VDD VDD sky130_fd_sc_hd__fill_1
* cell instance sky130_fd_sc_hd__fill_1_765 r0 *1 0,0
Xsky130_fd_sc_hd__fill_1_765 VSS VDD VDD sky130_fd_sc_hd__fill_1
* cell instance sky130_fd_sc_hd__fill_1_766 r0 *1 0,0
Xsky130_fd_sc_hd__fill_1_766 VSS VDD VDD sky130_fd_sc_hd__fill_1
* cell instance sky130_fd_sc_hd__fill_1_767 r0 *1 0,0
Xsky130_fd_sc_hd__fill_1_767 VSS VDD VDD sky130_fd_sc_hd__fill_1
* cell instance sky130_fd_sc_hd__fill_1_768 r0 *1 0,0
Xsky130_fd_sc_hd__fill_1_768 VSS VDD VDD sky130_fd_sc_hd__fill_1
* cell instance sky130_fd_sc_hd__fill_1_769 r0 *1 0,0
Xsky130_fd_sc_hd__fill_1_769 VSS VDD VDD sky130_fd_sc_hd__fill_1
* cell instance sky130_fd_sc_hd__fill_1_770 r0 *1 0,0
Xsky130_fd_sc_hd__fill_1_770 VSS VDD VDD sky130_fd_sc_hd__fill_1
* cell instance sky130_fd_sc_hd__fill_1_771 r0 *1 0,0
Xsky130_fd_sc_hd__fill_1_771 VSS VDD VDD sky130_fd_sc_hd__fill_1
* cell instance sky130_fd_sc_hd__fill_1_772 r0 *1 0,0
Xsky130_fd_sc_hd__fill_1_772 VSS VDD VDD sky130_fd_sc_hd__fill_1
* cell instance sky130_fd_sc_hd__fill_1_773 r0 *1 0,0
Xsky130_fd_sc_hd__fill_1_773 VSS VDD VDD sky130_fd_sc_hd__fill_1
* cell instance sky130_fd_sc_hd__fill_1_774 r0 *1 0,0
Xsky130_fd_sc_hd__fill_1_774 VSS VDD VDD sky130_fd_sc_hd__fill_1
* cell instance sky130_fd_sc_hd__fill_1_775 r0 *1 0,0
Xsky130_fd_sc_hd__fill_1_775 VSS VDD VDD sky130_fd_sc_hd__fill_1
* cell instance sky130_fd_sc_hd__fill_1_776 r0 *1 0,0
Xsky130_fd_sc_hd__fill_1_776 VSS VDD VDD sky130_fd_sc_hd__fill_1
* cell instance sky130_fd_sc_hd__fill_1_777 r0 *1 0,0
Xsky130_fd_sc_hd__fill_1_777 VSS VDD VDD sky130_fd_sc_hd__fill_1
* cell instance sky130_fd_sc_hd__fill_1_778 r0 *1 0,0
Xsky130_fd_sc_hd__fill_1_778 VSS VDD VDD sky130_fd_sc_hd__fill_1
* cell instance sky130_fd_sc_hd__fill_1_779 r0 *1 0,0
Xsky130_fd_sc_hd__fill_1_779 VSS VDD VDD sky130_fd_sc_hd__fill_1
* cell instance sky130_fd_sc_hd__fill_1_780 r0 *1 0,0
Xsky130_fd_sc_hd__fill_1_780 VSS VDD VDD sky130_fd_sc_hd__fill_1
* cell instance sky130_fd_sc_hd__fill_1_781 r0 *1 0,0
Xsky130_fd_sc_hd__fill_1_781 VSS VDD VDD sky130_fd_sc_hd__fill_1
* cell instance sky130_fd_sc_hd__fill_1_782 r0 *1 0,0
Xsky130_fd_sc_hd__fill_1_782 VSS VDD VDD sky130_fd_sc_hd__fill_1
* cell instance sky130_fd_sc_hd__fill_1_783 r0 *1 0,0
Xsky130_fd_sc_hd__fill_1_783 VSS VDD VDD sky130_fd_sc_hd__fill_1
* cell instance sky130_fd_sc_hd__fill_1_784 r0 *1 0,0
Xsky130_fd_sc_hd__fill_1_784 VSS VDD VDD sky130_fd_sc_hd__fill_1
* cell instance sky130_fd_sc_hd__fill_1_785 r0 *1 0,0
Xsky130_fd_sc_hd__fill_1_785 VSS VDD VDD sky130_fd_sc_hd__fill_1
* cell instance sky130_fd_sc_hd__fill_1_786 r0 *1 0,0
Xsky130_fd_sc_hd__fill_1_786 VSS VDD VDD sky130_fd_sc_hd__fill_1
* cell instance sky130_fd_sc_hd__fill_1_787 r0 *1 0,0
Xsky130_fd_sc_hd__fill_1_787 VSS VDD VDD sky130_fd_sc_hd__fill_1
* cell instance sky130_fd_sc_hd__fill_1_788 r0 *1 0,0
Xsky130_fd_sc_hd__fill_1_788 VSS VDD VDD sky130_fd_sc_hd__fill_1
* cell instance sky130_fd_sc_hd__fill_1_789 r0 *1 0,0
Xsky130_fd_sc_hd__fill_1_789 VSS VDD VDD sky130_fd_sc_hd__fill_1
* cell instance sky130_fd_sc_hd__fill_1_790 r0 *1 0,0
Xsky130_fd_sc_hd__fill_1_790 VSS VDD VDD sky130_fd_sc_hd__fill_1
* cell instance sky130_fd_sc_hd__fill_1_791 r0 *1 0,0
Xsky130_fd_sc_hd__fill_1_791 VSS VDD VDD sky130_fd_sc_hd__fill_1
* cell instance sky130_fd_sc_hd__fill_1_792 r0 *1 0,0
Xsky130_fd_sc_hd__fill_1_792 VSS VDD VDD sky130_fd_sc_hd__fill_1
* cell instance sky130_fd_sc_hd__fill_1_793 r0 *1 0,0
Xsky130_fd_sc_hd__fill_1_793 VSS VDD VDD sky130_fd_sc_hd__fill_1
* cell instance sky130_fd_sc_hd__fill_1_794 r0 *1 0,0
Xsky130_fd_sc_hd__fill_1_794 VSS VDD VDD sky130_fd_sc_hd__fill_1
* cell instance sky130_fd_sc_hd__fill_1_795 r0 *1 0,0
Xsky130_fd_sc_hd__fill_1_795 VSS VDD VDD sky130_fd_sc_hd__fill_1
* cell instance sky130_fd_sc_hd__fill_1_796 r0 *1 0,0
Xsky130_fd_sc_hd__fill_1_796 VSS VDD VDD sky130_fd_sc_hd__fill_1
* cell instance sky130_fd_sc_hd__fill_1_797 r0 *1 0,0
Xsky130_fd_sc_hd__fill_1_797 VSS VDD VDD sky130_fd_sc_hd__fill_1
* cell instance sky130_fd_sc_hd__fill_1_798 r0 *1 0,0
Xsky130_fd_sc_hd__fill_1_798 VSS VDD VDD sky130_fd_sc_hd__fill_1
* cell instance sky130_fd_sc_hd__fill_1_799 r0 *1 0,0
Xsky130_fd_sc_hd__fill_1_799 VSS VDD VDD sky130_fd_sc_hd__fill_1
* cell instance sky130_fd_sc_hd__fill_1_800 r0 *1 0,0
Xsky130_fd_sc_hd__fill_1_800 VSS VDD VDD sky130_fd_sc_hd__fill_1
* cell instance sky130_fd_sc_hd__fill_1_801 r0 *1 0,0
Xsky130_fd_sc_hd__fill_1_801 VSS VDD VDD sky130_fd_sc_hd__fill_1
* cell instance sky130_fd_sc_hd__fill_1_802 r0 *1 0,0
Xsky130_fd_sc_hd__fill_1_802 VSS VDD VDD sky130_fd_sc_hd__fill_1
* cell instance sky130_fd_sc_hd__fill_1_803 r0 *1 0,0
Xsky130_fd_sc_hd__fill_1_803 VSS VDD VDD sky130_fd_sc_hd__fill_1
* cell instance sky130_fd_sc_hd__fill_1_804 r0 *1 0,0
Xsky130_fd_sc_hd__fill_1_804 VSS VDD VDD sky130_fd_sc_hd__fill_1
* cell instance sky130_fd_sc_hd__fill_1_805 r0 *1 0,0
Xsky130_fd_sc_hd__fill_1_805 VSS VDD VDD sky130_fd_sc_hd__fill_1
* cell instance sky130_fd_sc_hd__fill_1_806 r0 *1 0,0
Xsky130_fd_sc_hd__fill_1_806 VSS VDD VDD sky130_fd_sc_hd__fill_1
* cell instance sky130_fd_sc_hd__fill_1_807 r0 *1 0,0
Xsky130_fd_sc_hd__fill_1_807 VSS VDD VDD sky130_fd_sc_hd__fill_1
* cell instance sky130_fd_sc_hd__fill_1_808 r0 *1 0,0
Xsky130_fd_sc_hd__fill_1_808 VSS VDD VDD sky130_fd_sc_hd__fill_1
* cell instance sky130_fd_sc_hd__fill_1_809 r0 *1 0,0
Xsky130_fd_sc_hd__fill_1_809 VSS VDD VDD sky130_fd_sc_hd__fill_1
* cell instance sky130_fd_sc_hd__fill_1_810 r0 *1 0,0
Xsky130_fd_sc_hd__fill_1_810 VSS VDD VDD sky130_fd_sc_hd__fill_1
* cell instance sky130_fd_sc_hd__fill_2_0 r0 *1 0,0
Xsky130_fd_sc_hd__fill_2_0 VSS VDD VDD sky130_fd_sc_hd__fill_2
* cell instance sky130_fd_sc_hd__fill_2_1 r0 *1 0,0
Xsky130_fd_sc_hd__fill_2_1 VSS VDD VDD sky130_fd_sc_hd__fill_2
* cell instance sky130_fd_sc_hd__fill_2_2 r0 *1 0,0
Xsky130_fd_sc_hd__fill_2_2 VSS VDD VDD sky130_fd_sc_hd__fill_2
* cell instance sky130_fd_sc_hd__fill_2_3 r0 *1 0,0
Xsky130_fd_sc_hd__fill_2_3 VSS VDD VDD sky130_fd_sc_hd__fill_2
* cell instance sky130_fd_sc_hd__fill_2_4 r0 *1 0,0
Xsky130_fd_sc_hd__fill_2_4 VSS VDD VDD sky130_fd_sc_hd__fill_2
* cell instance sky130_fd_sc_hd__fill_2_5 r0 *1 0,0
Xsky130_fd_sc_hd__fill_2_5 VSS VDD VDD sky130_fd_sc_hd__fill_2
* cell instance sky130_fd_sc_hd__fill_2_6 r0 *1 0,0
Xsky130_fd_sc_hd__fill_2_6 VSS VDD VDD sky130_fd_sc_hd__fill_2
* cell instance sky130_fd_sc_hd__fill_2_7 r0 *1 0,0
Xsky130_fd_sc_hd__fill_2_7 VSS VDD VDD sky130_fd_sc_hd__fill_2
* cell instance sky130_fd_sc_hd__fill_2_8 r0 *1 0,0
Xsky130_fd_sc_hd__fill_2_8 VSS VDD VDD sky130_fd_sc_hd__fill_2
* cell instance sky130_fd_sc_hd__fill_2_9 r0 *1 0,0
Xsky130_fd_sc_hd__fill_2_9 VSS VDD VDD sky130_fd_sc_hd__fill_2
* cell instance sky130_fd_sc_hd__fill_2_10 r0 *1 0,0
Xsky130_fd_sc_hd__fill_2_10 VSS VDD VDD sky130_fd_sc_hd__fill_2
* cell instance sky130_fd_sc_hd__fill_2_11 r0 *1 0,0
Xsky130_fd_sc_hd__fill_2_11 VSS VDD VDD sky130_fd_sc_hd__fill_2
* cell instance sky130_fd_sc_hd__fill_2_12 r0 *1 0,0
Xsky130_fd_sc_hd__fill_2_12 VSS VDD VDD sky130_fd_sc_hd__fill_2
* cell instance sky130_fd_sc_hd__fill_2_13 r0 *1 0,0
Xsky130_fd_sc_hd__fill_2_13 VSS VDD VDD sky130_fd_sc_hd__fill_2
* cell instance sky130_fd_sc_hd__fill_2_14 r0 *1 0,0
Xsky130_fd_sc_hd__fill_2_14 VSS VDD VDD sky130_fd_sc_hd__fill_2
* cell instance sky130_fd_sc_hd__fill_2_15 r0 *1 0,0
Xsky130_fd_sc_hd__fill_2_15 VSS VDD VDD sky130_fd_sc_hd__fill_2
* cell instance sky130_fd_sc_hd__fill_2_16 r0 *1 0,0
Xsky130_fd_sc_hd__fill_2_16 VSS VDD VDD sky130_fd_sc_hd__fill_2
* cell instance sky130_fd_sc_hd__fill_2_17 r0 *1 0,0
Xsky130_fd_sc_hd__fill_2_17 VSS VDD VDD sky130_fd_sc_hd__fill_2
* cell instance sky130_fd_sc_hd__fill_2_18 r0 *1 0,0
Xsky130_fd_sc_hd__fill_2_18 VSS VDD VDD sky130_fd_sc_hd__fill_2
* cell instance sky130_fd_sc_hd__fill_2_19 r0 *1 0,0
Xsky130_fd_sc_hd__fill_2_19 VSS VDD VDD sky130_fd_sc_hd__fill_2
* cell instance sky130_fd_sc_hd__fill_2_20 r0 *1 0,0
Xsky130_fd_sc_hd__fill_2_20 VSS VDD VDD sky130_fd_sc_hd__fill_2
* cell instance sky130_fd_sc_hd__fill_2_21 r0 *1 0,0
Xsky130_fd_sc_hd__fill_2_21 VSS VDD VDD sky130_fd_sc_hd__fill_2
* cell instance sky130_fd_sc_hd__fill_2_22 r0 *1 0,0
Xsky130_fd_sc_hd__fill_2_22 VSS VDD VDD sky130_fd_sc_hd__fill_2
* cell instance sky130_fd_sc_hd__fill_2_23 r0 *1 0,0
Xsky130_fd_sc_hd__fill_2_23 VSS VDD VDD sky130_fd_sc_hd__fill_2
* cell instance sky130_fd_sc_hd__fill_2_24 r0 *1 0,0
Xsky130_fd_sc_hd__fill_2_24 VSS VDD VDD sky130_fd_sc_hd__fill_2
* cell instance sky130_fd_sc_hd__fill_2_25 r0 *1 0,0
Xsky130_fd_sc_hd__fill_2_25 VSS VDD VDD sky130_fd_sc_hd__fill_2
* cell instance sky130_fd_sc_hd__fill_2_26 r0 *1 0,0
Xsky130_fd_sc_hd__fill_2_26 VSS VDD VDD sky130_fd_sc_hd__fill_2
* cell instance sky130_fd_sc_hd__fill_2_27 r0 *1 0,0
Xsky130_fd_sc_hd__fill_2_27 VSS VDD VDD sky130_fd_sc_hd__fill_2
* cell instance sky130_fd_sc_hd__fill_2_28 r0 *1 0,0
Xsky130_fd_sc_hd__fill_2_28 VSS VDD VDD sky130_fd_sc_hd__fill_2
* cell instance sky130_fd_sc_hd__fill_2_29 r0 *1 0,0
Xsky130_fd_sc_hd__fill_2_29 VSS VDD VDD sky130_fd_sc_hd__fill_2
* cell instance sky130_fd_sc_hd__fill_2_30 r0 *1 0,0
Xsky130_fd_sc_hd__fill_2_30 VSS VDD VDD sky130_fd_sc_hd__fill_2
* cell instance sky130_fd_sc_hd__fill_2_31 r0 *1 0,0
Xsky130_fd_sc_hd__fill_2_31 VSS VDD VDD sky130_fd_sc_hd__fill_2
* cell instance sky130_fd_sc_hd__fill_2_32 r0 *1 0,0
Xsky130_fd_sc_hd__fill_2_32 VSS VDD VDD sky130_fd_sc_hd__fill_2
* cell instance sky130_fd_sc_hd__fill_2_33 r0 *1 0,0
Xsky130_fd_sc_hd__fill_2_33 VSS VDD VDD sky130_fd_sc_hd__fill_2
* cell instance sky130_fd_sc_hd__fill_2_34 r0 *1 0,0
Xsky130_fd_sc_hd__fill_2_34 VSS VDD VDD sky130_fd_sc_hd__fill_2
* cell instance sky130_fd_sc_hd__fill_2_35 r0 *1 0,0
Xsky130_fd_sc_hd__fill_2_35 VSS VDD VDD sky130_fd_sc_hd__fill_2
* cell instance sky130_fd_sc_hd__fill_2_36 r0 *1 0,0
Xsky130_fd_sc_hd__fill_2_36 VSS VDD VDD sky130_fd_sc_hd__fill_2
* cell instance sky130_fd_sc_hd__fill_2_37 r0 *1 0,0
Xsky130_fd_sc_hd__fill_2_37 VSS VDD VDD sky130_fd_sc_hd__fill_2
* cell instance sky130_fd_sc_hd__fill_2_38 r0 *1 0,0
Xsky130_fd_sc_hd__fill_2_38 VSS VDD VDD sky130_fd_sc_hd__fill_2
* cell instance sky130_fd_sc_hd__fill_2_39 r0 *1 0,0
Xsky130_fd_sc_hd__fill_2_39 VSS VDD VDD sky130_fd_sc_hd__fill_2
* cell instance sky130_fd_sc_hd__fill_2_40 r0 *1 0,0
Xsky130_fd_sc_hd__fill_2_40 VSS VDD VDD sky130_fd_sc_hd__fill_2
* cell instance sky130_fd_sc_hd__fill_2_41 r0 *1 0,0
Xsky130_fd_sc_hd__fill_2_41 VSS VDD VDD sky130_fd_sc_hd__fill_2
* cell instance sky130_fd_sc_hd__fill_2_42 r0 *1 0,0
Xsky130_fd_sc_hd__fill_2_42 VSS VDD VDD sky130_fd_sc_hd__fill_2
* cell instance sky130_fd_sc_hd__fill_2_43 r0 *1 0,0
Xsky130_fd_sc_hd__fill_2_43 VSS VDD VDD sky130_fd_sc_hd__fill_2
* cell instance sky130_fd_sc_hd__fill_2_44 r0 *1 0,0
Xsky130_fd_sc_hd__fill_2_44 VSS VDD VDD sky130_fd_sc_hd__fill_2
* cell instance sky130_fd_sc_hd__fill_2_45 r0 *1 0,0
Xsky130_fd_sc_hd__fill_2_45 VSS VDD VDD sky130_fd_sc_hd__fill_2
* cell instance sky130_fd_sc_hd__fill_2_46 r0 *1 0,0
Xsky130_fd_sc_hd__fill_2_46 VSS VDD VDD sky130_fd_sc_hd__fill_2
* cell instance sky130_fd_sc_hd__fill_2_47 r0 *1 0,0
Xsky130_fd_sc_hd__fill_2_47 VSS VDD VDD sky130_fd_sc_hd__fill_2
* cell instance sky130_fd_sc_hd__fill_2_48 r0 *1 0,0
Xsky130_fd_sc_hd__fill_2_48 VSS VDD VDD sky130_fd_sc_hd__fill_2
* cell instance sky130_fd_sc_hd__fill_2_49 r0 *1 0,0
Xsky130_fd_sc_hd__fill_2_49 VSS VDD VDD sky130_fd_sc_hd__fill_2
* cell instance sky130_fd_sc_hd__fill_2_50 r0 *1 0,0
Xsky130_fd_sc_hd__fill_2_50 VSS VDD VDD sky130_fd_sc_hd__fill_2
* cell instance sky130_fd_sc_hd__fill_2_51 r0 *1 0,0
Xsky130_fd_sc_hd__fill_2_51 VSS VDD VDD sky130_fd_sc_hd__fill_2
* cell instance sky130_fd_sc_hd__fill_2_52 r0 *1 0,0
Xsky130_fd_sc_hd__fill_2_52 VSS VDD VDD sky130_fd_sc_hd__fill_2
* cell instance sky130_fd_sc_hd__fill_2_53 r0 *1 0,0
Xsky130_fd_sc_hd__fill_2_53 VSS VDD VDD sky130_fd_sc_hd__fill_2
* cell instance sky130_fd_sc_hd__fill_2_54 r0 *1 0,0
Xsky130_fd_sc_hd__fill_2_54 VSS VDD VDD sky130_fd_sc_hd__fill_2
* cell instance sky130_fd_sc_hd__fill_2_55 r0 *1 0,0
Xsky130_fd_sc_hd__fill_2_55 VSS VDD VDD sky130_fd_sc_hd__fill_2
* cell instance sky130_fd_sc_hd__fill_2_56 r0 *1 0,0
Xsky130_fd_sc_hd__fill_2_56 VSS VDD VDD sky130_fd_sc_hd__fill_2
* cell instance sky130_fd_sc_hd__fill_2_57 r0 *1 0,0
Xsky130_fd_sc_hd__fill_2_57 VSS VDD VDD sky130_fd_sc_hd__fill_2
* cell instance sky130_fd_sc_hd__fill_2_58 r0 *1 0,0
Xsky130_fd_sc_hd__fill_2_58 VSS VDD VDD sky130_fd_sc_hd__fill_2
* cell instance sky130_fd_sc_hd__fill_2_59 r0 *1 0,0
Xsky130_fd_sc_hd__fill_2_59 VSS VDD VDD sky130_fd_sc_hd__fill_2
* cell instance sky130_fd_sc_hd__fill_2_60 r0 *1 0,0
Xsky130_fd_sc_hd__fill_2_60 VSS VDD VDD sky130_fd_sc_hd__fill_2
* cell instance sky130_fd_sc_hd__fill_2_61 r0 *1 0,0
Xsky130_fd_sc_hd__fill_2_61 VSS VDD VDD sky130_fd_sc_hd__fill_2
* cell instance sky130_fd_sc_hd__fill_2_62 r0 *1 0,0
Xsky130_fd_sc_hd__fill_2_62 VSS VDD VDD sky130_fd_sc_hd__fill_2
* cell instance sky130_fd_sc_hd__fill_2_63 r0 *1 0,0
Xsky130_fd_sc_hd__fill_2_63 VSS VDD VDD sky130_fd_sc_hd__fill_2
* cell instance sky130_fd_sc_hd__fill_2_64 r0 *1 0,0
Xsky130_fd_sc_hd__fill_2_64 VSS VDD VDD sky130_fd_sc_hd__fill_2
* cell instance sky130_fd_sc_hd__fill_2_65 r0 *1 0,0
Xsky130_fd_sc_hd__fill_2_65 VSS VDD VDD sky130_fd_sc_hd__fill_2
* cell instance sky130_fd_sc_hd__fill_2_66 r0 *1 0,0
Xsky130_fd_sc_hd__fill_2_66 VSS VDD VDD sky130_fd_sc_hd__fill_2
* cell instance sky130_fd_sc_hd__fill_2_67 r0 *1 0,0
Xsky130_fd_sc_hd__fill_2_67 VSS VDD VDD sky130_fd_sc_hd__fill_2
* cell instance sky130_fd_sc_hd__fill_2_68 r0 *1 0,0
Xsky130_fd_sc_hd__fill_2_68 VSS VDD VDD sky130_fd_sc_hd__fill_2
* cell instance sky130_fd_sc_hd__fill_2_69 r0 *1 0,0
Xsky130_fd_sc_hd__fill_2_69 VSS VDD VDD sky130_fd_sc_hd__fill_2
* cell instance sky130_fd_sc_hd__fill_2_70 r0 *1 0,0
Xsky130_fd_sc_hd__fill_2_70 VSS VDD VDD sky130_fd_sc_hd__fill_2
* cell instance sky130_fd_sc_hd__fill_2_71 r0 *1 0,0
Xsky130_fd_sc_hd__fill_2_71 VSS VDD VDD sky130_fd_sc_hd__fill_2
* cell instance sky130_fd_sc_hd__fill_2_72 r0 *1 0,0
Xsky130_fd_sc_hd__fill_2_72 VSS VDD VDD sky130_fd_sc_hd__fill_2
* cell instance sky130_fd_sc_hd__fill_2_73 r0 *1 0,0
Xsky130_fd_sc_hd__fill_2_73 VSS VDD VDD sky130_fd_sc_hd__fill_2
* cell instance sky130_fd_sc_hd__fill_2_74 r0 *1 0,0
Xsky130_fd_sc_hd__fill_2_74 VSS VDD VDD sky130_fd_sc_hd__fill_2
* cell instance sky130_fd_sc_hd__fill_2_75 r0 *1 0,0
Xsky130_fd_sc_hd__fill_2_75 VSS VDD VDD sky130_fd_sc_hd__fill_2
* cell instance sky130_fd_sc_hd__fill_2_76 r0 *1 0,0
Xsky130_fd_sc_hd__fill_2_76 VSS VDD VDD sky130_fd_sc_hd__fill_2
* cell instance sky130_fd_sc_hd__fill_2_77 r0 *1 0,0
Xsky130_fd_sc_hd__fill_2_77 VSS VDD VDD sky130_fd_sc_hd__fill_2
* cell instance sky130_fd_sc_hd__fill_2_78 r0 *1 0,0
Xsky130_fd_sc_hd__fill_2_78 VSS VDD VDD sky130_fd_sc_hd__fill_2
* cell instance sky130_fd_sc_hd__fill_2_79 r0 *1 0,0
Xsky130_fd_sc_hd__fill_2_79 VSS VDD VDD sky130_fd_sc_hd__fill_2
* cell instance sky130_fd_sc_hd__fill_2_80 r0 *1 0,0
Xsky130_fd_sc_hd__fill_2_80 VSS VDD VDD sky130_fd_sc_hd__fill_2
* cell instance sky130_fd_sc_hd__fill_2_81 r0 *1 0,0
Xsky130_fd_sc_hd__fill_2_81 VSS VDD VDD sky130_fd_sc_hd__fill_2
* cell instance sky130_fd_sc_hd__fill_2_82 r0 *1 0,0
Xsky130_fd_sc_hd__fill_2_82 VSS VDD VDD sky130_fd_sc_hd__fill_2
* cell instance sky130_fd_sc_hd__fill_2_83 r0 *1 0,0
Xsky130_fd_sc_hd__fill_2_83 VSS VDD VDD sky130_fd_sc_hd__fill_2
* cell instance sky130_fd_sc_hd__fill_2_84 r0 *1 0,0
Xsky130_fd_sc_hd__fill_2_84 VSS VDD VDD sky130_fd_sc_hd__fill_2
* cell instance sky130_fd_sc_hd__fill_2_85 r0 *1 0,0
Xsky130_fd_sc_hd__fill_2_85 VSS VDD VDD sky130_fd_sc_hd__fill_2
* cell instance sky130_fd_sc_hd__fill_2_86 r0 *1 0,0
Xsky130_fd_sc_hd__fill_2_86 VSS VDD VDD sky130_fd_sc_hd__fill_2
* cell instance sky130_fd_sc_hd__fill_2_87 r0 *1 0,0
Xsky130_fd_sc_hd__fill_2_87 VSS VDD VDD sky130_fd_sc_hd__fill_2
* cell instance sky130_fd_sc_hd__fill_2_88 r0 *1 0,0
Xsky130_fd_sc_hd__fill_2_88 VSS VDD VDD sky130_fd_sc_hd__fill_2
* cell instance sky130_fd_sc_hd__fill_2_89 r0 *1 0,0
Xsky130_fd_sc_hd__fill_2_89 VSS VDD VDD sky130_fd_sc_hd__fill_2
* cell instance sky130_fd_sc_hd__fill_2_90 r0 *1 0,0
Xsky130_fd_sc_hd__fill_2_90 VSS VDD VDD sky130_fd_sc_hd__fill_2
* cell instance sky130_fd_sc_hd__fill_2_91 r0 *1 0,0
Xsky130_fd_sc_hd__fill_2_91 VSS VDD VDD sky130_fd_sc_hd__fill_2
* cell instance sky130_fd_sc_hd__fill_2_92 r0 *1 0,0
Xsky130_fd_sc_hd__fill_2_92 VSS VDD VDD sky130_fd_sc_hd__fill_2
* cell instance sky130_fd_sc_hd__fill_2_93 r0 *1 0,0
Xsky130_fd_sc_hd__fill_2_93 VSS VDD VDD sky130_fd_sc_hd__fill_2
* cell instance sky130_fd_sc_hd__fill_2_94 r0 *1 0,0
Xsky130_fd_sc_hd__fill_2_94 VSS VDD VDD sky130_fd_sc_hd__fill_2
* cell instance sky130_fd_sc_hd__fill_2_95 r0 *1 0,0
Xsky130_fd_sc_hd__fill_2_95 VSS VDD VDD sky130_fd_sc_hd__fill_2
* cell instance sky130_fd_sc_hd__fill_2_96 r0 *1 0,0
Xsky130_fd_sc_hd__fill_2_96 VSS VDD VDD sky130_fd_sc_hd__fill_2
* cell instance sky130_fd_sc_hd__fill_2_97 r0 *1 0,0
Xsky130_fd_sc_hd__fill_2_97 VSS VDD VDD sky130_fd_sc_hd__fill_2
* cell instance sky130_fd_sc_hd__fill_2_98 r0 *1 0,0
Xsky130_fd_sc_hd__fill_2_98 VSS VDD VDD sky130_fd_sc_hd__fill_2
* cell instance sky130_fd_sc_hd__fill_2_99 r0 *1 0,0
Xsky130_fd_sc_hd__fill_2_99 VSS VDD VDD sky130_fd_sc_hd__fill_2
* cell instance sky130_fd_sc_hd__fill_2_100 r0 *1 0,0
Xsky130_fd_sc_hd__fill_2_100 VSS VDD VDD sky130_fd_sc_hd__fill_2
* cell instance sky130_fd_sc_hd__fill_2_101 r0 *1 0,0
Xsky130_fd_sc_hd__fill_2_101 VSS VDD VDD sky130_fd_sc_hd__fill_2
* cell instance sky130_fd_sc_hd__fill_2_102 r0 *1 0,0
Xsky130_fd_sc_hd__fill_2_102 VSS VDD VDD sky130_fd_sc_hd__fill_2
* cell instance sky130_fd_sc_hd__fill_2_103 r0 *1 0,0
Xsky130_fd_sc_hd__fill_2_103 VSS VDD VDD sky130_fd_sc_hd__fill_2
* cell instance sky130_fd_sc_hd__fill_2_104 r0 *1 0,0
Xsky130_fd_sc_hd__fill_2_104 VSS VDD VDD sky130_fd_sc_hd__fill_2
* cell instance sky130_fd_sc_hd__fill_2_105 r0 *1 0,0
Xsky130_fd_sc_hd__fill_2_105 VSS VDD VDD sky130_fd_sc_hd__fill_2
* cell instance sky130_fd_sc_hd__fill_2_106 r0 *1 0,0
Xsky130_fd_sc_hd__fill_2_106 VSS VDD VDD sky130_fd_sc_hd__fill_2
* cell instance sky130_fd_sc_hd__fill_2_107 r0 *1 0,0
Xsky130_fd_sc_hd__fill_2_107 VSS VDD VDD sky130_fd_sc_hd__fill_2
* cell instance sky130_fd_sc_hd__fill_2_108 r0 *1 0,0
Xsky130_fd_sc_hd__fill_2_108 VSS VDD VDD sky130_fd_sc_hd__fill_2
* cell instance sky130_fd_sc_hd__fill_2_109 r0 *1 0,0
Xsky130_fd_sc_hd__fill_2_109 VSS VDD VDD sky130_fd_sc_hd__fill_2
* cell instance sky130_fd_sc_hd__fill_2_110 r0 *1 0,0
Xsky130_fd_sc_hd__fill_2_110 VSS VDD VDD sky130_fd_sc_hd__fill_2
* cell instance sky130_fd_sc_hd__fill_2_111 r0 *1 0,0
Xsky130_fd_sc_hd__fill_2_111 VSS VDD VDD sky130_fd_sc_hd__fill_2
* cell instance sky130_fd_sc_hd__fill_2_112 r0 *1 0,0
Xsky130_fd_sc_hd__fill_2_112 VSS VDD VDD sky130_fd_sc_hd__fill_2
* cell instance sky130_fd_sc_hd__fill_2_113 r0 *1 0,0
Xsky130_fd_sc_hd__fill_2_113 VSS VDD VDD sky130_fd_sc_hd__fill_2
* cell instance sky130_fd_sc_hd__fill_2_114 r0 *1 0,0
Xsky130_fd_sc_hd__fill_2_114 VSS VDD VDD sky130_fd_sc_hd__fill_2
* cell instance sky130_fd_sc_hd__fill_2_115 r0 *1 0,0
Xsky130_fd_sc_hd__fill_2_115 VSS VDD VDD sky130_fd_sc_hd__fill_2
* cell instance sky130_fd_sc_hd__fill_2_116 r0 *1 0,0
Xsky130_fd_sc_hd__fill_2_116 VSS VDD VDD sky130_fd_sc_hd__fill_2
* cell instance sky130_fd_sc_hd__fill_2_117 r0 *1 0,0
Xsky130_fd_sc_hd__fill_2_117 VSS VDD VDD sky130_fd_sc_hd__fill_2
* cell instance sky130_fd_sc_hd__fill_2_118 r0 *1 0,0
Xsky130_fd_sc_hd__fill_2_118 VSS VDD VDD sky130_fd_sc_hd__fill_2
* cell instance sky130_fd_sc_hd__fill_2_119 r0 *1 0,0
Xsky130_fd_sc_hd__fill_2_119 VSS VDD VDD sky130_fd_sc_hd__fill_2
* cell instance sky130_fd_sc_hd__fill_2_120 r0 *1 0,0
Xsky130_fd_sc_hd__fill_2_120 VSS VDD VDD sky130_fd_sc_hd__fill_2
* cell instance sky130_fd_sc_hd__fill_2_121 r0 *1 0,0
Xsky130_fd_sc_hd__fill_2_121 VSS VDD VDD sky130_fd_sc_hd__fill_2
* cell instance sky130_fd_sc_hd__fill_2_122 r0 *1 0,0
Xsky130_fd_sc_hd__fill_2_122 VSS VDD VDD sky130_fd_sc_hd__fill_2
* cell instance sky130_fd_sc_hd__fill_2_123 r0 *1 0,0
Xsky130_fd_sc_hd__fill_2_123 VSS VDD VDD sky130_fd_sc_hd__fill_2
* cell instance sky130_fd_sc_hd__fill_2_124 r0 *1 0,0
Xsky130_fd_sc_hd__fill_2_124 VSS VDD VDD sky130_fd_sc_hd__fill_2
* cell instance sky130_fd_sc_hd__fill_2_125 r0 *1 0,0
Xsky130_fd_sc_hd__fill_2_125 VSS VDD VDD sky130_fd_sc_hd__fill_2
* cell instance sky130_fd_sc_hd__fill_2_126 r0 *1 0,0
Xsky130_fd_sc_hd__fill_2_126 VSS VDD VDD sky130_fd_sc_hd__fill_2
* cell instance sky130_fd_sc_hd__fill_2_127 r0 *1 0,0
Xsky130_fd_sc_hd__fill_2_127 VSS VDD VDD sky130_fd_sc_hd__fill_2
* cell instance sky130_fd_sc_hd__fill_2_128 r0 *1 0,0
Xsky130_fd_sc_hd__fill_2_128 VSS VDD VDD sky130_fd_sc_hd__fill_2
* cell instance sky130_fd_sc_hd__fill_2_129 r0 *1 0,0
Xsky130_fd_sc_hd__fill_2_129 VSS VDD VDD sky130_fd_sc_hd__fill_2
* cell instance sky130_fd_sc_hd__fill_2_130 r0 *1 0,0
Xsky130_fd_sc_hd__fill_2_130 VSS VDD VDD sky130_fd_sc_hd__fill_2
* cell instance sky130_fd_sc_hd__fill_2_131 r0 *1 0,0
Xsky130_fd_sc_hd__fill_2_131 VSS VDD VDD sky130_fd_sc_hd__fill_2
* cell instance sky130_fd_sc_hd__fill_2_132 r0 *1 0,0
Xsky130_fd_sc_hd__fill_2_132 VSS VDD VDD sky130_fd_sc_hd__fill_2
* cell instance sky130_fd_sc_hd__fill_2_133 r0 *1 0,0
Xsky130_fd_sc_hd__fill_2_133 VSS VDD VDD sky130_fd_sc_hd__fill_2
* cell instance sky130_fd_sc_hd__fill_2_134 r0 *1 0,0
Xsky130_fd_sc_hd__fill_2_134 VSS VDD VDD sky130_fd_sc_hd__fill_2
* cell instance sky130_fd_sc_hd__fill_2_135 r0 *1 0,0
Xsky130_fd_sc_hd__fill_2_135 VSS VDD VDD sky130_fd_sc_hd__fill_2
* cell instance sky130_fd_sc_hd__fill_2_136 r0 *1 0,0
Xsky130_fd_sc_hd__fill_2_136 VSS VDD VDD sky130_fd_sc_hd__fill_2
* cell instance sky130_fd_sc_hd__fill_2_137 r0 *1 0,0
Xsky130_fd_sc_hd__fill_2_137 VSS VDD VDD sky130_fd_sc_hd__fill_2
* cell instance sky130_fd_sc_hd__fill_2_138 r0 *1 0,0
Xsky130_fd_sc_hd__fill_2_138 VSS VDD VDD sky130_fd_sc_hd__fill_2
* cell instance sky130_fd_sc_hd__fill_2_139 r0 *1 0,0
Xsky130_fd_sc_hd__fill_2_139 VSS VDD VDD sky130_fd_sc_hd__fill_2
* cell instance sky130_fd_sc_hd__fill_2_140 r0 *1 0,0
Xsky130_fd_sc_hd__fill_2_140 VSS VDD VDD sky130_fd_sc_hd__fill_2
* cell instance sky130_fd_sc_hd__fill_2_141 r0 *1 0,0
Xsky130_fd_sc_hd__fill_2_141 VSS VDD VDD sky130_fd_sc_hd__fill_2
* cell instance sky130_fd_sc_hd__fill_2_142 r0 *1 0,0
Xsky130_fd_sc_hd__fill_2_142 VSS VDD VDD sky130_fd_sc_hd__fill_2
* cell instance sky130_fd_sc_hd__fill_2_143 r0 *1 0,0
Xsky130_fd_sc_hd__fill_2_143 VSS VDD VDD sky130_fd_sc_hd__fill_2
* cell instance sky130_fd_sc_hd__fill_2_144 r0 *1 0,0
Xsky130_fd_sc_hd__fill_2_144 VSS VDD VDD sky130_fd_sc_hd__fill_2
* cell instance sky130_fd_sc_hd__fill_2_145 r0 *1 0,0
Xsky130_fd_sc_hd__fill_2_145 VSS VDD VDD sky130_fd_sc_hd__fill_2
* cell instance sky130_fd_sc_hd__fill_2_146 r0 *1 0,0
Xsky130_fd_sc_hd__fill_2_146 VSS VDD VDD sky130_fd_sc_hd__fill_2
* cell instance sky130_fd_sc_hd__fill_2_147 r0 *1 0,0
Xsky130_fd_sc_hd__fill_2_147 VSS VDD VDD sky130_fd_sc_hd__fill_2
* cell instance sky130_fd_sc_hd__fill_2_148 r0 *1 0,0
Xsky130_fd_sc_hd__fill_2_148 VSS VDD VDD sky130_fd_sc_hd__fill_2
* cell instance sky130_fd_sc_hd__fill_2_149 r0 *1 0,0
Xsky130_fd_sc_hd__fill_2_149 VSS VDD VDD sky130_fd_sc_hd__fill_2
* cell instance sky130_fd_sc_hd__fill_2_150 r0 *1 0,0
Xsky130_fd_sc_hd__fill_2_150 VSS VDD VDD sky130_fd_sc_hd__fill_2
* cell instance sky130_fd_sc_hd__fill_2_151 r0 *1 0,0
Xsky130_fd_sc_hd__fill_2_151 VSS VDD VDD sky130_fd_sc_hd__fill_2
* cell instance sky130_fd_sc_hd__fill_2_152 r0 *1 0,0
Xsky130_fd_sc_hd__fill_2_152 VSS VDD VDD sky130_fd_sc_hd__fill_2
* cell instance sky130_fd_sc_hd__fill_2_153 r0 *1 0,0
Xsky130_fd_sc_hd__fill_2_153 VSS VDD VDD sky130_fd_sc_hd__fill_2
* cell instance sky130_fd_sc_hd__fill_2_154 r0 *1 0,0
Xsky130_fd_sc_hd__fill_2_154 VSS VDD VDD sky130_fd_sc_hd__fill_2
* cell instance sky130_fd_sc_hd__fill_2_155 r0 *1 0,0
Xsky130_fd_sc_hd__fill_2_155 VSS VDD VDD sky130_fd_sc_hd__fill_2
* cell instance sky130_fd_sc_hd__fill_2_156 r0 *1 0,0
Xsky130_fd_sc_hd__fill_2_156 VSS VDD VDD sky130_fd_sc_hd__fill_2
* cell instance sky130_fd_sc_hd__fill_2_157 r0 *1 0,0
Xsky130_fd_sc_hd__fill_2_157 VSS VDD VDD sky130_fd_sc_hd__fill_2
* cell instance sky130_fd_sc_hd__fill_2_158 r0 *1 0,0
Xsky130_fd_sc_hd__fill_2_158 VSS VDD VDD sky130_fd_sc_hd__fill_2
* cell instance sky130_fd_sc_hd__fill_2_159 r0 *1 0,0
Xsky130_fd_sc_hd__fill_2_159 VSS VDD VDD sky130_fd_sc_hd__fill_2
* cell instance sky130_fd_sc_hd__fill_2_160 r0 *1 0,0
Xsky130_fd_sc_hd__fill_2_160 VSS VDD VDD sky130_fd_sc_hd__fill_2
* cell instance sky130_fd_sc_hd__fill_2_161 r0 *1 0,0
Xsky130_fd_sc_hd__fill_2_161 VSS VDD VDD sky130_fd_sc_hd__fill_2
* cell instance sky130_fd_sc_hd__fill_2_162 r0 *1 0,0
Xsky130_fd_sc_hd__fill_2_162 VSS VDD VDD sky130_fd_sc_hd__fill_2
* cell instance sky130_fd_sc_hd__fill_2_163 r0 *1 0,0
Xsky130_fd_sc_hd__fill_2_163 VSS VDD VDD sky130_fd_sc_hd__fill_2
* cell instance sky130_fd_sc_hd__fill_2_164 r0 *1 0,0
Xsky130_fd_sc_hd__fill_2_164 VSS VDD VDD sky130_fd_sc_hd__fill_2
* cell instance sky130_fd_sc_hd__fill_2_165 r0 *1 0,0
Xsky130_fd_sc_hd__fill_2_165 VSS VDD VDD sky130_fd_sc_hd__fill_2
* cell instance sky130_fd_sc_hd__fill_2_166 r0 *1 0,0
Xsky130_fd_sc_hd__fill_2_166 VSS VDD VDD sky130_fd_sc_hd__fill_2
* cell instance sky130_fd_sc_hd__fill_2_167 r0 *1 0,0
Xsky130_fd_sc_hd__fill_2_167 VSS VDD VDD sky130_fd_sc_hd__fill_2
* cell instance sky130_fd_sc_hd__fill_2_168 r0 *1 0,0
Xsky130_fd_sc_hd__fill_2_168 VSS VDD VDD sky130_fd_sc_hd__fill_2
* cell instance sky130_fd_sc_hd__fill_2_169 r0 *1 0,0
Xsky130_fd_sc_hd__fill_2_169 VSS VDD VDD sky130_fd_sc_hd__fill_2
* cell instance sky130_fd_sc_hd__fill_2_170 r0 *1 0,0
Xsky130_fd_sc_hd__fill_2_170 VSS VDD VDD sky130_fd_sc_hd__fill_2
* cell instance sky130_fd_sc_hd__fill_2_171 r0 *1 0,0
Xsky130_fd_sc_hd__fill_2_171 VSS VDD VDD sky130_fd_sc_hd__fill_2
* cell instance sky130_fd_sc_hd__fill_2_172 r0 *1 0,0
Xsky130_fd_sc_hd__fill_2_172 VSS VDD VDD sky130_fd_sc_hd__fill_2
* cell instance sky130_fd_sc_hd__fill_2_173 r0 *1 0,0
Xsky130_fd_sc_hd__fill_2_173 VSS VDD VDD sky130_fd_sc_hd__fill_2
* cell instance sky130_fd_sc_hd__fill_2_174 r0 *1 0,0
Xsky130_fd_sc_hd__fill_2_174 VSS VDD VDD sky130_fd_sc_hd__fill_2
* cell instance sky130_fd_sc_hd__fill_2_175 r0 *1 0,0
Xsky130_fd_sc_hd__fill_2_175 VSS VDD VDD sky130_fd_sc_hd__fill_2
* cell instance sky130_fd_sc_hd__fill_2_176 r0 *1 0,0
Xsky130_fd_sc_hd__fill_2_176 VSS VDD VDD sky130_fd_sc_hd__fill_2
* cell instance sky130_fd_sc_hd__fill_2_177 r0 *1 0,0
Xsky130_fd_sc_hd__fill_2_177 VSS VDD VDD sky130_fd_sc_hd__fill_2
* cell instance sky130_fd_sc_hd__fill_2_178 r0 *1 0,0
Xsky130_fd_sc_hd__fill_2_178 VSS VDD VDD sky130_fd_sc_hd__fill_2
* cell instance sky130_fd_sc_hd__fill_2_179 r0 *1 0,0
Xsky130_fd_sc_hd__fill_2_179 VSS VDD VDD sky130_fd_sc_hd__fill_2
* cell instance sky130_fd_sc_hd__fill_2_180 r0 *1 0,0
Xsky130_fd_sc_hd__fill_2_180 VSS VDD VDD sky130_fd_sc_hd__fill_2
* cell instance sky130_fd_sc_hd__fill_2_181 r0 *1 0,0
Xsky130_fd_sc_hd__fill_2_181 VSS VDD VDD sky130_fd_sc_hd__fill_2
* cell instance sky130_fd_sc_hd__fill_2_182 r0 *1 0,0
Xsky130_fd_sc_hd__fill_2_182 VSS VDD VDD sky130_fd_sc_hd__fill_2
* cell instance sky130_fd_sc_hd__fill_2_183 r0 *1 0,0
Xsky130_fd_sc_hd__fill_2_183 VSS VDD VDD sky130_fd_sc_hd__fill_2
* cell instance sky130_fd_sc_hd__fill_2_184 r0 *1 0,0
Xsky130_fd_sc_hd__fill_2_184 VSS VDD VDD sky130_fd_sc_hd__fill_2
* cell instance sky130_fd_sc_hd__fill_2_185 r0 *1 0,0
Xsky130_fd_sc_hd__fill_2_185 VSS VDD VDD sky130_fd_sc_hd__fill_2
* cell instance sky130_fd_sc_hd__fill_2_186 r0 *1 0,0
Xsky130_fd_sc_hd__fill_2_186 VSS VDD VDD sky130_fd_sc_hd__fill_2
* cell instance sky130_fd_sc_hd__fill_2_187 r0 *1 0,0
Xsky130_fd_sc_hd__fill_2_187 VSS VDD VDD sky130_fd_sc_hd__fill_2
* cell instance sky130_fd_sc_hd__fill_2_188 r0 *1 0,0
Xsky130_fd_sc_hd__fill_2_188 VSS VDD VDD sky130_fd_sc_hd__fill_2
* cell instance sky130_fd_sc_hd__fill_2_189 r0 *1 0,0
Xsky130_fd_sc_hd__fill_2_189 VSS VDD VDD sky130_fd_sc_hd__fill_2
* cell instance sky130_fd_sc_hd__fill_2_190 r0 *1 0,0
Xsky130_fd_sc_hd__fill_2_190 VSS VDD VDD sky130_fd_sc_hd__fill_2
* cell instance sky130_fd_sc_hd__fill_2_191 r0 *1 0,0
Xsky130_fd_sc_hd__fill_2_191 VSS VDD VDD sky130_fd_sc_hd__fill_2
* cell instance sky130_fd_sc_hd__fill_2_192 r0 *1 0,0
Xsky130_fd_sc_hd__fill_2_192 VSS VDD VDD sky130_fd_sc_hd__fill_2
* cell instance sky130_fd_sc_hd__fill_2_193 r0 *1 0,0
Xsky130_fd_sc_hd__fill_2_193 VSS VDD VDD sky130_fd_sc_hd__fill_2
* cell instance sky130_fd_sc_hd__fill_2_194 r0 *1 0,0
Xsky130_fd_sc_hd__fill_2_194 VSS VDD VDD sky130_fd_sc_hd__fill_2
* cell instance sky130_fd_sc_hd__fill_2_195 r0 *1 0,0
Xsky130_fd_sc_hd__fill_2_195 VSS VDD VDD sky130_fd_sc_hd__fill_2
* cell instance sky130_fd_sc_hd__fill_2_196 r0 *1 0,0
Xsky130_fd_sc_hd__fill_2_196 VSS VDD VDD sky130_fd_sc_hd__fill_2
* cell instance sky130_fd_sc_hd__fill_2_197 r0 *1 0,0
Xsky130_fd_sc_hd__fill_2_197 VSS VDD VDD sky130_fd_sc_hd__fill_2
* cell instance sky130_fd_sc_hd__fill_2_198 r0 *1 0,0
Xsky130_fd_sc_hd__fill_2_198 VSS VDD VDD sky130_fd_sc_hd__fill_2
* cell instance sky130_fd_sc_hd__fill_2_199 r0 *1 0,0
Xsky130_fd_sc_hd__fill_2_199 VSS VDD VDD sky130_fd_sc_hd__fill_2
* cell instance sky130_fd_sc_hd__fill_2_200 r0 *1 0,0
Xsky130_fd_sc_hd__fill_2_200 VSS VDD VDD sky130_fd_sc_hd__fill_2
* cell instance sky130_fd_sc_hd__fill_2_201 r0 *1 0,0
Xsky130_fd_sc_hd__fill_2_201 VSS VDD VDD sky130_fd_sc_hd__fill_2
* cell instance sky130_fd_sc_hd__fill_2_202 r0 *1 0,0
Xsky130_fd_sc_hd__fill_2_202 VSS VDD VDD sky130_fd_sc_hd__fill_2
* cell instance sky130_fd_sc_hd__fill_2_203 r0 *1 0,0
Xsky130_fd_sc_hd__fill_2_203 VSS VDD VDD sky130_fd_sc_hd__fill_2
* cell instance sky130_fd_sc_hd__fill_2_204 r0 *1 0,0
Xsky130_fd_sc_hd__fill_2_204 VSS VDD VDD sky130_fd_sc_hd__fill_2
* cell instance sky130_fd_sc_hd__fill_2_205 r0 *1 0,0
Xsky130_fd_sc_hd__fill_2_205 VSS VDD VDD sky130_fd_sc_hd__fill_2
* cell instance sky130_fd_sc_hd__fill_2_206 r0 *1 0,0
Xsky130_fd_sc_hd__fill_2_206 VSS VDD VDD sky130_fd_sc_hd__fill_2
* cell instance sky130_fd_sc_hd__fill_2_207 r0 *1 0,0
Xsky130_fd_sc_hd__fill_2_207 VSS VDD VDD sky130_fd_sc_hd__fill_2
* cell instance sky130_fd_sc_hd__fill_2_208 r0 *1 0,0
Xsky130_fd_sc_hd__fill_2_208 VSS VDD VDD sky130_fd_sc_hd__fill_2
* cell instance sky130_fd_sc_hd__fill_2_209 r0 *1 0,0
Xsky130_fd_sc_hd__fill_2_209 VSS VDD VDD sky130_fd_sc_hd__fill_2
* cell instance sky130_fd_sc_hd__fill_2_210 r0 *1 0,0
Xsky130_fd_sc_hd__fill_2_210 VSS VDD VDD sky130_fd_sc_hd__fill_2
* cell instance sky130_fd_sc_hd__fill_2_211 r0 *1 0,0
Xsky130_fd_sc_hd__fill_2_211 VSS VDD VDD sky130_fd_sc_hd__fill_2
* cell instance sky130_fd_sc_hd__fill_2_212 r0 *1 0,0
Xsky130_fd_sc_hd__fill_2_212 VSS VDD VDD sky130_fd_sc_hd__fill_2
* cell instance sky130_fd_sc_hd__fill_2_213 r0 *1 0,0
Xsky130_fd_sc_hd__fill_2_213 VSS VDD VDD sky130_fd_sc_hd__fill_2
* cell instance sky130_fd_sc_hd__fill_2_214 r0 *1 0,0
Xsky130_fd_sc_hd__fill_2_214 VSS VDD VDD sky130_fd_sc_hd__fill_2
* cell instance sky130_fd_sc_hd__fill_2_215 r0 *1 0,0
Xsky130_fd_sc_hd__fill_2_215 VSS VDD VDD sky130_fd_sc_hd__fill_2
* cell instance sky130_fd_sc_hd__fill_2_216 r0 *1 0,0
Xsky130_fd_sc_hd__fill_2_216 VSS VDD VDD sky130_fd_sc_hd__fill_2
* cell instance sky130_fd_sc_hd__fill_2_217 r0 *1 0,0
Xsky130_fd_sc_hd__fill_2_217 VSS VDD VDD sky130_fd_sc_hd__fill_2
* cell instance sky130_fd_sc_hd__fill_2_218 r0 *1 0,0
Xsky130_fd_sc_hd__fill_2_218 VSS VDD VDD sky130_fd_sc_hd__fill_2
* cell instance sky130_fd_sc_hd__fill_2_219 r0 *1 0,0
Xsky130_fd_sc_hd__fill_2_219 VSS VDD VDD sky130_fd_sc_hd__fill_2
* cell instance sky130_fd_sc_hd__fill_2_220 r0 *1 0,0
Xsky130_fd_sc_hd__fill_2_220 VSS VDD VDD sky130_fd_sc_hd__fill_2
* cell instance sky130_fd_sc_hd__fill_2_221 r0 *1 0,0
Xsky130_fd_sc_hd__fill_2_221 VSS VDD VDD sky130_fd_sc_hd__fill_2
* cell instance sky130_fd_sc_hd__fill_2_222 r0 *1 0,0
Xsky130_fd_sc_hd__fill_2_222 VSS VDD VDD sky130_fd_sc_hd__fill_2
* cell instance sky130_fd_sc_hd__fill_2_223 r0 *1 0,0
Xsky130_fd_sc_hd__fill_2_223 VSS VDD VDD sky130_fd_sc_hd__fill_2
* cell instance sky130_fd_sc_hd__fill_2_224 r0 *1 0,0
Xsky130_fd_sc_hd__fill_2_224 VSS VDD VDD sky130_fd_sc_hd__fill_2
* cell instance sky130_fd_sc_hd__fill_2_225 r0 *1 0,0
Xsky130_fd_sc_hd__fill_2_225 VSS VDD VDD sky130_fd_sc_hd__fill_2
* cell instance sky130_fd_sc_hd__fill_2_226 r0 *1 0,0
Xsky130_fd_sc_hd__fill_2_226 VSS VDD VDD sky130_fd_sc_hd__fill_2
* cell instance sky130_fd_sc_hd__fill_2_227 r0 *1 0,0
Xsky130_fd_sc_hd__fill_2_227 VSS VDD VDD sky130_fd_sc_hd__fill_2
* cell instance sky130_fd_sc_hd__fill_2_228 r0 *1 0,0
Xsky130_fd_sc_hd__fill_2_228 VSS VDD VDD sky130_fd_sc_hd__fill_2
* cell instance sky130_fd_sc_hd__fill_2_229 r0 *1 0,0
Xsky130_fd_sc_hd__fill_2_229 VSS VDD VDD sky130_fd_sc_hd__fill_2
* cell instance sky130_fd_sc_hd__fill_2_230 r0 *1 0,0
Xsky130_fd_sc_hd__fill_2_230 VSS VDD VDD sky130_fd_sc_hd__fill_2
* cell instance sky130_fd_sc_hd__fill_2_231 r0 *1 0,0
Xsky130_fd_sc_hd__fill_2_231 VSS VDD VDD sky130_fd_sc_hd__fill_2
* cell instance sky130_fd_sc_hd__fill_2_232 r0 *1 0,0
Xsky130_fd_sc_hd__fill_2_232 VSS VDD VDD sky130_fd_sc_hd__fill_2
* cell instance sky130_fd_sc_hd__fill_2_233 r0 *1 0,0
Xsky130_fd_sc_hd__fill_2_233 VSS VDD VDD sky130_fd_sc_hd__fill_2
* cell instance sky130_fd_sc_hd__fill_2_234 r0 *1 0,0
Xsky130_fd_sc_hd__fill_2_234 VSS VDD VDD sky130_fd_sc_hd__fill_2
* cell instance sky130_fd_sc_hd__fill_2_235 r0 *1 0,0
Xsky130_fd_sc_hd__fill_2_235 VSS VDD VDD sky130_fd_sc_hd__fill_2
* cell instance sky130_fd_sc_hd__fill_2_236 r0 *1 0,0
Xsky130_fd_sc_hd__fill_2_236 VSS VDD VDD sky130_fd_sc_hd__fill_2
* cell instance sky130_fd_sc_hd__fill_2_237 r0 *1 0,0
Xsky130_fd_sc_hd__fill_2_237 VSS VDD VDD sky130_fd_sc_hd__fill_2
* cell instance sky130_fd_sc_hd__fill_2_238 r0 *1 0,0
Xsky130_fd_sc_hd__fill_2_238 VSS VDD VDD sky130_fd_sc_hd__fill_2
* cell instance sky130_fd_sc_hd__fill_2_239 r0 *1 0,0
Xsky130_fd_sc_hd__fill_2_239 VSS VDD VDD sky130_fd_sc_hd__fill_2
* cell instance sky130_fd_sc_hd__fill_2_240 r0 *1 0,0
Xsky130_fd_sc_hd__fill_2_240 VSS VDD VDD sky130_fd_sc_hd__fill_2
* cell instance sky130_fd_sc_hd__fill_2_241 r0 *1 0,0
Xsky130_fd_sc_hd__fill_2_241 VSS VDD VDD sky130_fd_sc_hd__fill_2
* cell instance sky130_fd_sc_hd__fill_2_242 r0 *1 0,0
Xsky130_fd_sc_hd__fill_2_242 VSS VDD VDD sky130_fd_sc_hd__fill_2
* cell instance sky130_fd_sc_hd__fill_2_243 r0 *1 0,0
Xsky130_fd_sc_hd__fill_2_243 VSS VDD VDD sky130_fd_sc_hd__fill_2
* cell instance sky130_fd_sc_hd__fill_2_244 r0 *1 0,0
Xsky130_fd_sc_hd__fill_2_244 VSS VDD VDD sky130_fd_sc_hd__fill_2
* cell instance sky130_fd_sc_hd__fill_2_245 r0 *1 0,0
Xsky130_fd_sc_hd__fill_2_245 VSS VDD VDD sky130_fd_sc_hd__fill_2
* cell instance sky130_fd_sc_hd__fill_2_246 r0 *1 0,0
Xsky130_fd_sc_hd__fill_2_246 VSS VDD VDD sky130_fd_sc_hd__fill_2
* cell instance sky130_fd_sc_hd__fill_2_247 r0 *1 0,0
Xsky130_fd_sc_hd__fill_2_247 VSS VDD VDD sky130_fd_sc_hd__fill_2
* cell instance sky130_fd_sc_hd__fill_2_248 r0 *1 0,0
Xsky130_fd_sc_hd__fill_2_248 VSS VDD VDD sky130_fd_sc_hd__fill_2
* cell instance sky130_fd_sc_hd__fill_2_249 r0 *1 0,0
Xsky130_fd_sc_hd__fill_2_249 VSS VDD VDD sky130_fd_sc_hd__fill_2
* cell instance sky130_fd_sc_hd__fill_2_250 r0 *1 0,0
Xsky130_fd_sc_hd__fill_2_250 VSS VDD VDD sky130_fd_sc_hd__fill_2
* cell instance sky130_fd_sc_hd__fill_2_251 r0 *1 0,0
Xsky130_fd_sc_hd__fill_2_251 VSS VDD VDD sky130_fd_sc_hd__fill_2
* cell instance sky130_fd_sc_hd__fill_2_252 r0 *1 0,0
Xsky130_fd_sc_hd__fill_2_252 VSS VDD VDD sky130_fd_sc_hd__fill_2
* cell instance sky130_fd_sc_hd__fill_2_253 r0 *1 0,0
Xsky130_fd_sc_hd__fill_2_253 VSS VDD VDD sky130_fd_sc_hd__fill_2
* cell instance sky130_fd_sc_hd__fill_2_254 r0 *1 0,0
Xsky130_fd_sc_hd__fill_2_254 VSS VDD VDD sky130_fd_sc_hd__fill_2
* cell instance sky130_fd_sc_hd__fill_2_255 r0 *1 0,0
Xsky130_fd_sc_hd__fill_2_255 VSS VDD VDD sky130_fd_sc_hd__fill_2
* cell instance sky130_fd_sc_hd__fill_2_256 r0 *1 0,0
Xsky130_fd_sc_hd__fill_2_256 VSS VDD VDD sky130_fd_sc_hd__fill_2
* cell instance sky130_fd_sc_hd__fill_2_257 r0 *1 0,0
Xsky130_fd_sc_hd__fill_2_257 VSS VDD VDD sky130_fd_sc_hd__fill_2
* cell instance sky130_fd_sc_hd__fill_2_258 r0 *1 0,0
Xsky130_fd_sc_hd__fill_2_258 VSS VDD VDD sky130_fd_sc_hd__fill_2
* cell instance sky130_fd_sc_hd__fill_2_259 r0 *1 0,0
Xsky130_fd_sc_hd__fill_2_259 VSS VDD VDD sky130_fd_sc_hd__fill_2
* cell instance sky130_fd_sc_hd__fill_2_260 r0 *1 0,0
Xsky130_fd_sc_hd__fill_2_260 VSS VDD VDD sky130_fd_sc_hd__fill_2
* cell instance sky130_fd_sc_hd__fill_2_261 r0 *1 0,0
Xsky130_fd_sc_hd__fill_2_261 VSS VDD VDD sky130_fd_sc_hd__fill_2
* cell instance sky130_fd_sc_hd__fill_2_262 r0 *1 0,0
Xsky130_fd_sc_hd__fill_2_262 VSS VDD VDD sky130_fd_sc_hd__fill_2
* cell instance sky130_fd_sc_hd__fill_2_263 r0 *1 0,0
Xsky130_fd_sc_hd__fill_2_263 VSS VDD VDD sky130_fd_sc_hd__fill_2
* cell instance sky130_fd_sc_hd__fill_2_264 r0 *1 0,0
Xsky130_fd_sc_hd__fill_2_264 VSS VDD VDD sky130_fd_sc_hd__fill_2
* cell instance sky130_fd_sc_hd__fill_2_265 r0 *1 0,0
Xsky130_fd_sc_hd__fill_2_265 VSS VDD VDD sky130_fd_sc_hd__fill_2
* cell instance sky130_fd_sc_hd__fill_2_266 r0 *1 0,0
Xsky130_fd_sc_hd__fill_2_266 VSS VDD VDD sky130_fd_sc_hd__fill_2
* cell instance sky130_fd_sc_hd__fill_2_267 r0 *1 0,0
Xsky130_fd_sc_hd__fill_2_267 VSS VDD VDD sky130_fd_sc_hd__fill_2
* cell instance sky130_fd_sc_hd__fill_2_268 r0 *1 0,0
Xsky130_fd_sc_hd__fill_2_268 VSS VDD VDD sky130_fd_sc_hd__fill_2
* cell instance sky130_fd_sc_hd__fill_2_269 r0 *1 0,0
Xsky130_fd_sc_hd__fill_2_269 VSS VDD VDD sky130_fd_sc_hd__fill_2
* cell instance sky130_fd_sc_hd__fill_2_270 r0 *1 0,0
Xsky130_fd_sc_hd__fill_2_270 VSS VDD VDD sky130_fd_sc_hd__fill_2
* cell instance sky130_fd_sc_hd__fill_2_271 r0 *1 0,0
Xsky130_fd_sc_hd__fill_2_271 VSS VDD VDD sky130_fd_sc_hd__fill_2
* cell instance sky130_fd_sc_hd__fill_2_272 r0 *1 0,0
Xsky130_fd_sc_hd__fill_2_272 VSS VDD VDD sky130_fd_sc_hd__fill_2
* cell instance sky130_fd_sc_hd__fill_2_273 r0 *1 0,0
Xsky130_fd_sc_hd__fill_2_273 VSS VDD VDD sky130_fd_sc_hd__fill_2
* cell instance sky130_fd_sc_hd__fill_2_274 r0 *1 0,0
Xsky130_fd_sc_hd__fill_2_274 VSS VDD VDD sky130_fd_sc_hd__fill_2
* cell instance sky130_fd_sc_hd__fill_2_275 r0 *1 0,0
Xsky130_fd_sc_hd__fill_2_275 VSS VDD VDD sky130_fd_sc_hd__fill_2
* cell instance sky130_fd_sc_hd__fill_2_276 r0 *1 0,0
Xsky130_fd_sc_hd__fill_2_276 VSS VDD VDD sky130_fd_sc_hd__fill_2
* cell instance sky130_fd_sc_hd__fill_2_277 r0 *1 0,0
Xsky130_fd_sc_hd__fill_2_277 VSS VDD VDD sky130_fd_sc_hd__fill_2
* cell instance sky130_fd_sc_hd__fill_2_278 r0 *1 0,0
Xsky130_fd_sc_hd__fill_2_278 VSS VDD VDD sky130_fd_sc_hd__fill_2
* cell instance sky130_fd_sc_hd__fill_2_279 r0 *1 0,0
Xsky130_fd_sc_hd__fill_2_279 VSS VDD VDD sky130_fd_sc_hd__fill_2
* cell instance sky130_fd_sc_hd__fill_2_280 r0 *1 0,0
Xsky130_fd_sc_hd__fill_2_280 VSS VDD VDD sky130_fd_sc_hd__fill_2
* cell instance sky130_fd_sc_hd__fill_2_281 r0 *1 0,0
Xsky130_fd_sc_hd__fill_2_281 VSS VDD VDD sky130_fd_sc_hd__fill_2
* cell instance sky130_fd_sc_hd__fill_2_282 r0 *1 0,0
Xsky130_fd_sc_hd__fill_2_282 VSS VDD VDD sky130_fd_sc_hd__fill_2
* cell instance sky130_fd_sc_hd__fill_2_283 r0 *1 0,0
Xsky130_fd_sc_hd__fill_2_283 VSS VDD VDD sky130_fd_sc_hd__fill_2
* cell instance sky130_fd_sc_hd__fill_2_284 r0 *1 0,0
Xsky130_fd_sc_hd__fill_2_284 VSS VDD VDD sky130_fd_sc_hd__fill_2
* cell instance sky130_fd_sc_hd__fill_2_285 r0 *1 0,0
Xsky130_fd_sc_hd__fill_2_285 VSS VDD VDD sky130_fd_sc_hd__fill_2
* cell instance sky130_fd_sc_hd__fill_2_286 r0 *1 0,0
Xsky130_fd_sc_hd__fill_2_286 VSS VDD VDD sky130_fd_sc_hd__fill_2
* cell instance sky130_fd_sc_hd__fill_2_287 r0 *1 0,0
Xsky130_fd_sc_hd__fill_2_287 VSS VDD VDD sky130_fd_sc_hd__fill_2
* cell instance sky130_fd_sc_hd__fill_2_288 r0 *1 0,0
Xsky130_fd_sc_hd__fill_2_288 VSS VDD VDD sky130_fd_sc_hd__fill_2
* cell instance sky130_fd_sc_hd__fill_2_289 r0 *1 0,0
Xsky130_fd_sc_hd__fill_2_289 VSS VDD VDD sky130_fd_sc_hd__fill_2
* cell instance sky130_fd_sc_hd__fill_2_290 r0 *1 0,0
Xsky130_fd_sc_hd__fill_2_290 VSS VDD VDD sky130_fd_sc_hd__fill_2
* cell instance sky130_fd_sc_hd__fill_2_291 r0 *1 0,0
Xsky130_fd_sc_hd__fill_2_291 VSS VDD VDD sky130_fd_sc_hd__fill_2
* cell instance sky130_fd_sc_hd__fill_2_292 r0 *1 0,0
Xsky130_fd_sc_hd__fill_2_292 VSS VDD VDD sky130_fd_sc_hd__fill_2
* cell instance sky130_fd_sc_hd__fill_2_293 r0 *1 0,0
Xsky130_fd_sc_hd__fill_2_293 VSS VDD VDD sky130_fd_sc_hd__fill_2
* cell instance sky130_fd_sc_hd__fill_2_294 r0 *1 0,0
Xsky130_fd_sc_hd__fill_2_294 VSS VDD VDD sky130_fd_sc_hd__fill_2
* cell instance sky130_fd_sc_hd__fill_2_295 r0 *1 0,0
Xsky130_fd_sc_hd__fill_2_295 VSS VDD VDD sky130_fd_sc_hd__fill_2
* cell instance sky130_fd_sc_hd__fill_2_296 r0 *1 0,0
Xsky130_fd_sc_hd__fill_2_296 VSS VDD VDD sky130_fd_sc_hd__fill_2
* cell instance sky130_fd_sc_hd__fill_2_297 r0 *1 0,0
Xsky130_fd_sc_hd__fill_2_297 VSS VDD VDD sky130_fd_sc_hd__fill_2
* cell instance sky130_fd_sc_hd__fill_2_298 r0 *1 0,0
Xsky130_fd_sc_hd__fill_2_298 VSS VDD VDD sky130_fd_sc_hd__fill_2
* cell instance sky130_fd_sc_hd__fill_2_299 r0 *1 0,0
Xsky130_fd_sc_hd__fill_2_299 VSS VDD VDD sky130_fd_sc_hd__fill_2
* cell instance sky130_fd_sc_hd__fill_2_300 r0 *1 0,0
Xsky130_fd_sc_hd__fill_2_300 VSS VDD VDD sky130_fd_sc_hd__fill_2
* cell instance sky130_fd_sc_hd__fill_2_301 r0 *1 0,0
Xsky130_fd_sc_hd__fill_2_301 VSS VDD VDD sky130_fd_sc_hd__fill_2
* cell instance sky130_fd_sc_hd__fill_2_302 r0 *1 0,0
Xsky130_fd_sc_hd__fill_2_302 VSS VDD VDD sky130_fd_sc_hd__fill_2
* cell instance sky130_fd_sc_hd__fill_2_303 r0 *1 0,0
Xsky130_fd_sc_hd__fill_2_303 VSS VDD VDD sky130_fd_sc_hd__fill_2
* cell instance sky130_fd_sc_hd__fill_2_304 r0 *1 0,0
Xsky130_fd_sc_hd__fill_2_304 VSS VDD VDD sky130_fd_sc_hd__fill_2
* cell instance sky130_fd_sc_hd__fill_2_305 r0 *1 0,0
Xsky130_fd_sc_hd__fill_2_305 VSS VDD VDD sky130_fd_sc_hd__fill_2
* cell instance sky130_fd_sc_hd__fill_2_306 r0 *1 0,0
Xsky130_fd_sc_hd__fill_2_306 VSS VDD VDD sky130_fd_sc_hd__fill_2
* cell instance sky130_fd_sc_hd__fill_2_307 r0 *1 0,0
Xsky130_fd_sc_hd__fill_2_307 VSS VDD VDD sky130_fd_sc_hd__fill_2
* cell instance sky130_fd_sc_hd__fill_2_308 r0 *1 0,0
Xsky130_fd_sc_hd__fill_2_308 VSS VDD VDD sky130_fd_sc_hd__fill_2
* cell instance sky130_fd_sc_hd__fill_2_309 r0 *1 0,0
Xsky130_fd_sc_hd__fill_2_309 VSS VDD VDD sky130_fd_sc_hd__fill_2
* cell instance sky130_fd_sc_hd__fill_2_310 r0 *1 0,0
Xsky130_fd_sc_hd__fill_2_310 VSS VDD VDD sky130_fd_sc_hd__fill_2
* cell instance sky130_fd_sc_hd__fill_2_311 r0 *1 0,0
Xsky130_fd_sc_hd__fill_2_311 VSS VDD VDD sky130_fd_sc_hd__fill_2
* cell instance sky130_fd_sc_hd__fill_2_312 r0 *1 0,0
Xsky130_fd_sc_hd__fill_2_312 VSS VDD VDD sky130_fd_sc_hd__fill_2
* cell instance sky130_fd_sc_hd__fill_2_313 r0 *1 0,0
Xsky130_fd_sc_hd__fill_2_313 VSS VDD VDD sky130_fd_sc_hd__fill_2
* cell instance sky130_fd_sc_hd__fill_2_314 r0 *1 0,0
Xsky130_fd_sc_hd__fill_2_314 VSS VDD VDD sky130_fd_sc_hd__fill_2
* cell instance sky130_fd_sc_hd__fill_2_315 r0 *1 0,0
Xsky130_fd_sc_hd__fill_2_315 VSS VDD VDD sky130_fd_sc_hd__fill_2
* cell instance sky130_fd_sc_hd__fill_2_316 r0 *1 0,0
Xsky130_fd_sc_hd__fill_2_316 VSS VDD VDD sky130_fd_sc_hd__fill_2
* cell instance sky130_fd_sc_hd__fill_2_317 r0 *1 0,0
Xsky130_fd_sc_hd__fill_2_317 VSS VDD VDD sky130_fd_sc_hd__fill_2
* cell instance sky130_fd_sc_hd__fill_2_318 r0 *1 0,0
Xsky130_fd_sc_hd__fill_2_318 VSS VDD VDD sky130_fd_sc_hd__fill_2
* cell instance sky130_fd_sc_hd__fill_2_319 r0 *1 0,0
Xsky130_fd_sc_hd__fill_2_319 VSS VDD VDD sky130_fd_sc_hd__fill_2
* cell instance sky130_fd_sc_hd__fill_2_320 r0 *1 0,0
Xsky130_fd_sc_hd__fill_2_320 VSS VDD VDD sky130_fd_sc_hd__fill_2
* cell instance sky130_fd_sc_hd__fill_2_321 r0 *1 0,0
Xsky130_fd_sc_hd__fill_2_321 VSS VDD VDD sky130_fd_sc_hd__fill_2
* cell instance sky130_fd_sc_hd__fill_2_322 r0 *1 0,0
Xsky130_fd_sc_hd__fill_2_322 VSS VDD VDD sky130_fd_sc_hd__fill_2
* cell instance sky130_fd_sc_hd__fill_2_323 r0 *1 0,0
Xsky130_fd_sc_hd__fill_2_323 VSS VDD VDD sky130_fd_sc_hd__fill_2
* cell instance sky130_fd_sc_hd__fill_2_324 r0 *1 0,0
Xsky130_fd_sc_hd__fill_2_324 VSS VDD VDD sky130_fd_sc_hd__fill_2
* cell instance sky130_fd_sc_hd__fill_2_325 r0 *1 0,0
Xsky130_fd_sc_hd__fill_2_325 VSS VDD VDD sky130_fd_sc_hd__fill_2
* cell instance sky130_fd_sc_hd__fill_2_326 r0 *1 0,0
Xsky130_fd_sc_hd__fill_2_326 VSS VDD VDD sky130_fd_sc_hd__fill_2
* cell instance sky130_fd_sc_hd__fill_2_327 r0 *1 0,0
Xsky130_fd_sc_hd__fill_2_327 VSS VDD VDD sky130_fd_sc_hd__fill_2
* cell instance sky130_fd_sc_hd__fill_2_328 r0 *1 0,0
Xsky130_fd_sc_hd__fill_2_328 VSS VDD VDD sky130_fd_sc_hd__fill_2
* cell instance sky130_fd_sc_hd__fill_2_329 r0 *1 0,0
Xsky130_fd_sc_hd__fill_2_329 VSS VDD VDD sky130_fd_sc_hd__fill_2
* cell instance sky130_fd_sc_hd__fill_2_330 r0 *1 0,0
Xsky130_fd_sc_hd__fill_2_330 VSS VDD VDD sky130_fd_sc_hd__fill_2
* cell instance sky130_fd_sc_hd__fill_2_331 r0 *1 0,0
Xsky130_fd_sc_hd__fill_2_331 VSS VDD VDD sky130_fd_sc_hd__fill_2
* cell instance sky130_fd_sc_hd__fill_2_332 r0 *1 0,0
Xsky130_fd_sc_hd__fill_2_332 VSS VDD VDD sky130_fd_sc_hd__fill_2
* cell instance sky130_fd_sc_hd__fill_2_333 r0 *1 0,0
Xsky130_fd_sc_hd__fill_2_333 VSS VDD VDD sky130_fd_sc_hd__fill_2
* cell instance sky130_fd_sc_hd__fill_2_334 r0 *1 0,0
Xsky130_fd_sc_hd__fill_2_334 VSS VDD VDD sky130_fd_sc_hd__fill_2
* cell instance sky130_fd_sc_hd__fill_2_335 r0 *1 0,0
Xsky130_fd_sc_hd__fill_2_335 VSS VDD VDD sky130_fd_sc_hd__fill_2
* cell instance sky130_fd_sc_hd__fill_2_336 r0 *1 0,0
Xsky130_fd_sc_hd__fill_2_336 VSS VDD VDD sky130_fd_sc_hd__fill_2
* cell instance sky130_fd_sc_hd__fill_2_337 r0 *1 0,0
Xsky130_fd_sc_hd__fill_2_337 VSS VDD VDD sky130_fd_sc_hd__fill_2
* cell instance sky130_fd_sc_hd__fill_2_338 r0 *1 0,0
Xsky130_fd_sc_hd__fill_2_338 VSS VDD VDD sky130_fd_sc_hd__fill_2
* cell instance sky130_fd_sc_hd__fill_2_339 r0 *1 0,0
Xsky130_fd_sc_hd__fill_2_339 VSS VDD VDD sky130_fd_sc_hd__fill_2
* cell instance sky130_fd_sc_hd__fill_2_340 r0 *1 0,0
Xsky130_fd_sc_hd__fill_2_340 VSS VDD VDD sky130_fd_sc_hd__fill_2
* cell instance sky130_fd_sc_hd__fill_2_341 r0 *1 0,0
Xsky130_fd_sc_hd__fill_2_341 VSS VDD VDD sky130_fd_sc_hd__fill_2
* cell instance sky130_fd_sc_hd__fill_2_342 r0 *1 0,0
Xsky130_fd_sc_hd__fill_2_342 VSS VDD VDD sky130_fd_sc_hd__fill_2
* cell instance sky130_fd_sc_hd__fill_2_343 r0 *1 0,0
Xsky130_fd_sc_hd__fill_2_343 VSS VDD VDD sky130_fd_sc_hd__fill_2
* cell instance sky130_fd_sc_hd__fill_2_344 r0 *1 0,0
Xsky130_fd_sc_hd__fill_2_344 VSS VDD VDD sky130_fd_sc_hd__fill_2
* cell instance sky130_fd_sc_hd__fill_2_345 r0 *1 0,0
Xsky130_fd_sc_hd__fill_2_345 VSS VDD VDD sky130_fd_sc_hd__fill_2
* cell instance sky130_fd_sc_hd__fill_2_346 r0 *1 0,0
Xsky130_fd_sc_hd__fill_2_346 VSS VDD VDD sky130_fd_sc_hd__fill_2
* cell instance sky130_fd_sc_hd__fill_2_347 r0 *1 0,0
Xsky130_fd_sc_hd__fill_2_347 VSS VDD VDD sky130_fd_sc_hd__fill_2
* cell instance sky130_fd_sc_hd__fill_2_348 r0 *1 0,0
Xsky130_fd_sc_hd__fill_2_348 VSS VDD VDD sky130_fd_sc_hd__fill_2
* cell instance sky130_fd_sc_hd__fill_2_349 r0 *1 0,0
Xsky130_fd_sc_hd__fill_2_349 VSS VDD VDD sky130_fd_sc_hd__fill_2
* cell instance sky130_fd_sc_hd__fill_2_350 r0 *1 0,0
Xsky130_fd_sc_hd__fill_2_350 VSS VDD VDD sky130_fd_sc_hd__fill_2
* cell instance sky130_fd_sc_hd__fill_2_351 r0 *1 0,0
Xsky130_fd_sc_hd__fill_2_351 VSS VDD VDD sky130_fd_sc_hd__fill_2
* cell instance sky130_fd_sc_hd__fill_2_352 r0 *1 0,0
Xsky130_fd_sc_hd__fill_2_352 VSS VDD VDD sky130_fd_sc_hd__fill_2
* cell instance sky130_fd_sc_hd__fill_2_353 r0 *1 0,0
Xsky130_fd_sc_hd__fill_2_353 VSS VDD VDD sky130_fd_sc_hd__fill_2
* cell instance sky130_fd_sc_hd__fill_2_354 r0 *1 0,0
Xsky130_fd_sc_hd__fill_2_354 VSS VDD VDD sky130_fd_sc_hd__fill_2
* cell instance sky130_fd_sc_hd__fill_2_355 r0 *1 0,0
Xsky130_fd_sc_hd__fill_2_355 VSS VDD VDD sky130_fd_sc_hd__fill_2
* cell instance sky130_fd_sc_hd__fill_2_356 r0 *1 0,0
Xsky130_fd_sc_hd__fill_2_356 VSS VDD VDD sky130_fd_sc_hd__fill_2
* cell instance sky130_fd_sc_hd__fill_2_357 r0 *1 0,0
Xsky130_fd_sc_hd__fill_2_357 VSS VDD VDD sky130_fd_sc_hd__fill_2
* cell instance sky130_fd_sc_hd__fill_2_358 r0 *1 0,0
Xsky130_fd_sc_hd__fill_2_358 VSS VDD VDD sky130_fd_sc_hd__fill_2
* cell instance sky130_fd_sc_hd__fill_2_359 r0 *1 0,0
Xsky130_fd_sc_hd__fill_2_359 VSS VDD VDD sky130_fd_sc_hd__fill_2
* cell instance sky130_fd_sc_hd__fill_2_360 r0 *1 0,0
Xsky130_fd_sc_hd__fill_2_360 VSS VDD VDD sky130_fd_sc_hd__fill_2
* cell instance sky130_fd_sc_hd__fill_2_361 r0 *1 0,0
Xsky130_fd_sc_hd__fill_2_361 VSS VDD VDD sky130_fd_sc_hd__fill_2
* cell instance sky130_fd_sc_hd__fill_2_362 r0 *1 0,0
Xsky130_fd_sc_hd__fill_2_362 VSS VDD VDD sky130_fd_sc_hd__fill_2
* cell instance sky130_fd_sc_hd__fill_2_363 r0 *1 0,0
Xsky130_fd_sc_hd__fill_2_363 VSS VDD VDD sky130_fd_sc_hd__fill_2
* cell instance sky130_fd_sc_hd__fill_2_364 r0 *1 0,0
Xsky130_fd_sc_hd__fill_2_364 VSS VDD VDD sky130_fd_sc_hd__fill_2
* cell instance sky130_fd_sc_hd__fill_2_365 r0 *1 0,0
Xsky130_fd_sc_hd__fill_2_365 VSS VDD VDD sky130_fd_sc_hd__fill_2
* cell instance sky130_fd_sc_hd__fill_2_366 r0 *1 0,0
Xsky130_fd_sc_hd__fill_2_366 VSS VDD VDD sky130_fd_sc_hd__fill_2
* cell instance sky130_fd_sc_hd__fill_2_367 r0 *1 0,0
Xsky130_fd_sc_hd__fill_2_367 VSS VDD VDD sky130_fd_sc_hd__fill_2
* cell instance sky130_fd_sc_hd__fill_2_368 r0 *1 0,0
Xsky130_fd_sc_hd__fill_2_368 VSS VDD VDD sky130_fd_sc_hd__fill_2
* cell instance sky130_fd_sc_hd__fill_2_369 r0 *1 0,0
Xsky130_fd_sc_hd__fill_2_369 VSS VDD VDD sky130_fd_sc_hd__fill_2
* cell instance sky130_fd_sc_hd__fill_2_370 r0 *1 0,0
Xsky130_fd_sc_hd__fill_2_370 VSS VDD VDD sky130_fd_sc_hd__fill_2
* cell instance sky130_fd_sc_hd__fill_2_371 r0 *1 0,0
Xsky130_fd_sc_hd__fill_2_371 VSS VDD VDD sky130_fd_sc_hd__fill_2
* cell instance sky130_fd_sc_hd__fill_2_372 r0 *1 0,0
Xsky130_fd_sc_hd__fill_2_372 VSS VDD VDD sky130_fd_sc_hd__fill_2
* cell instance sky130_fd_sc_hd__fill_2_373 r0 *1 0,0
Xsky130_fd_sc_hd__fill_2_373 VSS VDD VDD sky130_fd_sc_hd__fill_2
* cell instance sky130_fd_sc_hd__fill_2_374 r0 *1 0,0
Xsky130_fd_sc_hd__fill_2_374 VSS VDD VDD sky130_fd_sc_hd__fill_2
* cell instance sky130_fd_sc_hd__fill_2_375 r0 *1 0,0
Xsky130_fd_sc_hd__fill_2_375 VSS VDD VDD sky130_fd_sc_hd__fill_2
* cell instance sky130_fd_sc_hd__fill_2_376 r0 *1 0,0
Xsky130_fd_sc_hd__fill_2_376 VSS VDD VDD sky130_fd_sc_hd__fill_2
* cell instance sky130_fd_sc_hd__fill_2_377 r0 *1 0,0
Xsky130_fd_sc_hd__fill_2_377 VSS VDD VDD sky130_fd_sc_hd__fill_2
* cell instance sky130_fd_sc_hd__fill_2_378 r0 *1 0,0
Xsky130_fd_sc_hd__fill_2_378 VSS VDD VDD sky130_fd_sc_hd__fill_2
* cell instance sky130_fd_sc_hd__fill_2_379 r0 *1 0,0
Xsky130_fd_sc_hd__fill_2_379 VSS VDD VDD sky130_fd_sc_hd__fill_2
* cell instance sky130_fd_sc_hd__fill_2_380 r0 *1 0,0
Xsky130_fd_sc_hd__fill_2_380 VSS VDD VDD sky130_fd_sc_hd__fill_2
* cell instance sky130_fd_sc_hd__fill_2_381 r0 *1 0,0
Xsky130_fd_sc_hd__fill_2_381 VSS VDD VDD sky130_fd_sc_hd__fill_2
* cell instance sky130_fd_sc_hd__fill_2_382 r0 *1 0,0
Xsky130_fd_sc_hd__fill_2_382 VSS VDD VDD sky130_fd_sc_hd__fill_2
* cell instance sky130_fd_sc_hd__fill_2_383 r0 *1 0,0
Xsky130_fd_sc_hd__fill_2_383 VSS VDD VDD sky130_fd_sc_hd__fill_2
* cell instance sky130_fd_sc_hd__fill_2_384 r0 *1 0,0
Xsky130_fd_sc_hd__fill_2_384 VSS VDD VDD sky130_fd_sc_hd__fill_2
* cell instance sky130_fd_sc_hd__fill_2_385 r0 *1 0,0
Xsky130_fd_sc_hd__fill_2_385 VSS VDD VDD sky130_fd_sc_hd__fill_2
* cell instance sky130_fd_sc_hd__fill_2_386 r0 *1 0,0
Xsky130_fd_sc_hd__fill_2_386 VSS VDD VDD sky130_fd_sc_hd__fill_2
* cell instance sky130_fd_sc_hd__fill_2_387 r0 *1 0,0
Xsky130_fd_sc_hd__fill_2_387 VSS VDD VDD sky130_fd_sc_hd__fill_2
* cell instance sky130_fd_sc_hd__fill_2_388 r0 *1 0,0
Xsky130_fd_sc_hd__fill_2_388 VSS VDD VDD sky130_fd_sc_hd__fill_2
* cell instance sky130_fd_sc_hd__fill_2_389 r0 *1 0,0
Xsky130_fd_sc_hd__fill_2_389 VSS VDD VDD sky130_fd_sc_hd__fill_2
* cell instance sky130_fd_sc_hd__fill_2_390 r0 *1 0,0
Xsky130_fd_sc_hd__fill_2_390 VSS VDD VDD sky130_fd_sc_hd__fill_2
* cell instance sky130_fd_sc_hd__fill_2_391 r0 *1 0,0
Xsky130_fd_sc_hd__fill_2_391 VSS VDD VDD sky130_fd_sc_hd__fill_2
* cell instance sky130_fd_sc_hd__fill_2_392 r0 *1 0,0
Xsky130_fd_sc_hd__fill_2_392 VSS VDD VDD sky130_fd_sc_hd__fill_2
* cell instance sky130_fd_sc_hd__fill_2_393 r0 *1 0,0
Xsky130_fd_sc_hd__fill_2_393 VSS VDD VDD sky130_fd_sc_hd__fill_2
* cell instance sky130_fd_sc_hd__fill_2_394 r0 *1 0,0
Xsky130_fd_sc_hd__fill_2_394 VSS VDD VDD sky130_fd_sc_hd__fill_2
* cell instance sky130_fd_sc_hd__fill_2_395 r0 *1 0,0
Xsky130_fd_sc_hd__fill_2_395 VSS VDD VDD sky130_fd_sc_hd__fill_2
* cell instance sky130_fd_sc_hd__fill_2_396 r0 *1 0,0
Xsky130_fd_sc_hd__fill_2_396 VSS VDD VDD sky130_fd_sc_hd__fill_2
* cell instance sky130_fd_sc_hd__fill_2_397 r0 *1 0,0
Xsky130_fd_sc_hd__fill_2_397 VSS VDD VDD sky130_fd_sc_hd__fill_2
* cell instance sky130_fd_sc_hd__fill_2_398 r0 *1 0,0
Xsky130_fd_sc_hd__fill_2_398 VSS VDD VDD sky130_fd_sc_hd__fill_2
* cell instance sky130_fd_sc_hd__fill_2_399 r0 *1 0,0
Xsky130_fd_sc_hd__fill_2_399 VSS VDD VDD sky130_fd_sc_hd__fill_2
* cell instance sky130_fd_sc_hd__fill_2_400 r0 *1 0,0
Xsky130_fd_sc_hd__fill_2_400 VSS VDD VDD sky130_fd_sc_hd__fill_2
* cell instance sky130_fd_sc_hd__fill_2_401 r0 *1 0,0
Xsky130_fd_sc_hd__fill_2_401 VSS VDD VDD sky130_fd_sc_hd__fill_2
* cell instance sky130_fd_sc_hd__fill_2_402 r0 *1 0,0
Xsky130_fd_sc_hd__fill_2_402 VSS VDD VDD sky130_fd_sc_hd__fill_2
* cell instance sky130_fd_sc_hd__fill_2_403 r0 *1 0,0
Xsky130_fd_sc_hd__fill_2_403 VSS VDD VDD sky130_fd_sc_hd__fill_2
* cell instance sky130_fd_sc_hd__fill_2_404 r0 *1 0,0
Xsky130_fd_sc_hd__fill_2_404 VSS VDD VDD sky130_fd_sc_hd__fill_2
* cell instance sky130_fd_sc_hd__fill_2_405 r0 *1 0,0
Xsky130_fd_sc_hd__fill_2_405 VSS VDD VDD sky130_fd_sc_hd__fill_2
* cell instance sky130_fd_sc_hd__fill_2_406 r0 *1 0,0
Xsky130_fd_sc_hd__fill_2_406 VSS VDD VDD sky130_fd_sc_hd__fill_2
* cell instance sky130_fd_sc_hd__fill_2_407 r0 *1 0,0
Xsky130_fd_sc_hd__fill_2_407 VSS VDD VDD sky130_fd_sc_hd__fill_2
* cell instance sky130_fd_sc_hd__fill_2_408 r0 *1 0,0
Xsky130_fd_sc_hd__fill_2_408 VSS VDD VDD sky130_fd_sc_hd__fill_2
* cell instance sky130_fd_sc_hd__fill_2_409 r0 *1 0,0
Xsky130_fd_sc_hd__fill_2_409 VSS VDD VDD sky130_fd_sc_hd__fill_2
* cell instance sky130_fd_sc_hd__fill_2_410 r0 *1 0,0
Xsky130_fd_sc_hd__fill_2_410 VSS VDD VDD sky130_fd_sc_hd__fill_2
* cell instance sky130_fd_sc_hd__fill_2_411 r0 *1 0,0
Xsky130_fd_sc_hd__fill_2_411 VSS VDD VDD sky130_fd_sc_hd__fill_2
* cell instance sky130_fd_sc_hd__fill_2_412 r0 *1 0,0
Xsky130_fd_sc_hd__fill_2_412 VSS VDD VDD sky130_fd_sc_hd__fill_2
* cell instance sky130_fd_sc_hd__fill_2_413 r0 *1 0,0
Xsky130_fd_sc_hd__fill_2_413 VSS VDD VDD sky130_fd_sc_hd__fill_2
* cell instance sky130_fd_sc_hd__fill_2_414 r0 *1 0,0
Xsky130_fd_sc_hd__fill_2_414 VSS VDD VDD sky130_fd_sc_hd__fill_2
* cell instance sky130_fd_sc_hd__fill_2_415 r0 *1 0,0
Xsky130_fd_sc_hd__fill_2_415 VSS VDD VDD sky130_fd_sc_hd__fill_2
* cell instance sky130_fd_sc_hd__fill_2_416 r0 *1 0,0
Xsky130_fd_sc_hd__fill_2_416 VSS VDD VDD sky130_fd_sc_hd__fill_2
* cell instance sky130_fd_sc_hd__fill_2_417 r0 *1 0,0
Xsky130_fd_sc_hd__fill_2_417 VSS VDD VDD sky130_fd_sc_hd__fill_2
* cell instance sky130_fd_sc_hd__fill_2_418 r0 *1 0,0
Xsky130_fd_sc_hd__fill_2_418 VSS VDD VDD sky130_fd_sc_hd__fill_2
* cell instance sky130_fd_sc_hd__fill_2_419 r0 *1 0,0
Xsky130_fd_sc_hd__fill_2_419 VSS VDD VDD sky130_fd_sc_hd__fill_2
* cell instance sky130_fd_sc_hd__fill_2_420 r0 *1 0,0
Xsky130_fd_sc_hd__fill_2_420 VSS VDD VDD sky130_fd_sc_hd__fill_2
* cell instance sky130_fd_sc_hd__fill_2_421 r0 *1 0,0
Xsky130_fd_sc_hd__fill_2_421 VSS VDD VDD sky130_fd_sc_hd__fill_2
* cell instance sky130_fd_sc_hd__fill_2_422 r0 *1 0,0
Xsky130_fd_sc_hd__fill_2_422 VSS VDD VDD sky130_fd_sc_hd__fill_2
* cell instance sky130_fd_sc_hd__fill_2_423 r0 *1 0,0
Xsky130_fd_sc_hd__fill_2_423 VSS VDD VDD sky130_fd_sc_hd__fill_2
* cell instance sky130_fd_sc_hd__fill_2_424 r0 *1 0,0
Xsky130_fd_sc_hd__fill_2_424 VSS VDD VDD sky130_fd_sc_hd__fill_2
* cell instance sky130_fd_sc_hd__fill_2_425 r0 *1 0,0
Xsky130_fd_sc_hd__fill_2_425 VSS VDD VDD sky130_fd_sc_hd__fill_2
* cell instance sky130_fd_sc_hd__fill_2_426 r0 *1 0,0
Xsky130_fd_sc_hd__fill_2_426 VSS VDD VDD sky130_fd_sc_hd__fill_2
* cell instance sky130_fd_sc_hd__fill_2_427 r0 *1 0,0
Xsky130_fd_sc_hd__fill_2_427 VSS VDD VDD sky130_fd_sc_hd__fill_2
* cell instance sky130_fd_sc_hd__fill_2_428 r0 *1 0,0
Xsky130_fd_sc_hd__fill_2_428 VSS VDD VDD sky130_fd_sc_hd__fill_2
* cell instance sky130_fd_sc_hd__fill_2_429 r0 *1 0,0
Xsky130_fd_sc_hd__fill_2_429 VSS VDD VDD sky130_fd_sc_hd__fill_2
* cell instance sky130_fd_sc_hd__fill_2_430 r0 *1 0,0
Xsky130_fd_sc_hd__fill_2_430 VSS VDD VDD sky130_fd_sc_hd__fill_2
* cell instance sky130_fd_sc_hd__fill_2_431 r0 *1 0,0
Xsky130_fd_sc_hd__fill_2_431 VSS VDD VDD sky130_fd_sc_hd__fill_2
* cell instance sky130_fd_sc_hd__fill_2_432 r0 *1 0,0
Xsky130_fd_sc_hd__fill_2_432 VSS VDD VDD sky130_fd_sc_hd__fill_2
* cell instance sky130_fd_sc_hd__fill_2_433 r0 *1 0,0
Xsky130_fd_sc_hd__fill_2_433 VSS VDD VDD sky130_fd_sc_hd__fill_2
* cell instance sky130_fd_sc_hd__fill_2_434 r0 *1 0,0
Xsky130_fd_sc_hd__fill_2_434 VSS VDD VDD sky130_fd_sc_hd__fill_2
* cell instance sky130_fd_sc_hd__fill_2_435 r0 *1 0,0
Xsky130_fd_sc_hd__fill_2_435 VSS VDD VDD sky130_fd_sc_hd__fill_2
* cell instance sky130_fd_sc_hd__fill_2_436 r0 *1 0,0
Xsky130_fd_sc_hd__fill_2_436 VSS VDD VDD sky130_fd_sc_hd__fill_2
* cell instance sky130_fd_sc_hd__fill_2_437 r0 *1 0,0
Xsky130_fd_sc_hd__fill_2_437 VSS VDD VDD sky130_fd_sc_hd__fill_2
* cell instance sky130_fd_sc_hd__fill_2_438 r0 *1 0,0
Xsky130_fd_sc_hd__fill_2_438 VSS VDD VDD sky130_fd_sc_hd__fill_2
* cell instance sky130_fd_sc_hd__fill_2_439 r0 *1 0,0
Xsky130_fd_sc_hd__fill_2_439 VSS VDD VDD sky130_fd_sc_hd__fill_2
* cell instance sky130_fd_sc_hd__fill_2_440 r0 *1 0,0
Xsky130_fd_sc_hd__fill_2_440 VSS VDD VDD sky130_fd_sc_hd__fill_2
* cell instance sky130_fd_sc_hd__fill_2_441 r0 *1 0,0
Xsky130_fd_sc_hd__fill_2_441 VSS VDD VDD sky130_fd_sc_hd__fill_2
* cell instance sky130_fd_sc_hd__fill_2_442 r0 *1 0,0
Xsky130_fd_sc_hd__fill_2_442 VSS VDD VDD sky130_fd_sc_hd__fill_2
* cell instance sky130_fd_sc_hd__fill_2_443 r0 *1 0,0
Xsky130_fd_sc_hd__fill_2_443 VSS VDD VDD sky130_fd_sc_hd__fill_2
* cell instance sky130_fd_sc_hd__fill_2_444 r0 *1 0,0
Xsky130_fd_sc_hd__fill_2_444 VSS VDD VDD sky130_fd_sc_hd__fill_2
* cell instance sky130_fd_sc_hd__fill_2_445 r0 *1 0,0
Xsky130_fd_sc_hd__fill_2_445 VSS VDD VDD sky130_fd_sc_hd__fill_2
* cell instance sky130_fd_sc_hd__fill_2_446 r0 *1 0,0
Xsky130_fd_sc_hd__fill_2_446 VSS VDD VDD sky130_fd_sc_hd__fill_2
* cell instance sky130_fd_sc_hd__fill_2_447 r0 *1 0,0
Xsky130_fd_sc_hd__fill_2_447 VSS VDD VDD sky130_fd_sc_hd__fill_2
* cell instance sky130_fd_sc_hd__fill_2_448 r0 *1 0,0
Xsky130_fd_sc_hd__fill_2_448 VSS VDD VDD sky130_fd_sc_hd__fill_2
* cell instance sky130_fd_sc_hd__fill_2_449 r0 *1 0,0
Xsky130_fd_sc_hd__fill_2_449 VSS VDD VDD sky130_fd_sc_hd__fill_2
* cell instance sky130_fd_sc_hd__fill_2_450 r0 *1 0,0
Xsky130_fd_sc_hd__fill_2_450 VSS VDD VDD sky130_fd_sc_hd__fill_2
* cell instance sky130_fd_sc_hd__fill_2_451 r0 *1 0,0
Xsky130_fd_sc_hd__fill_2_451 VSS VDD VDD sky130_fd_sc_hd__fill_2
* cell instance sky130_fd_sc_hd__fill_2_452 r0 *1 0,0
Xsky130_fd_sc_hd__fill_2_452 VSS VDD VDD sky130_fd_sc_hd__fill_2
* cell instance sky130_fd_sc_hd__fill_2_453 r0 *1 0,0
Xsky130_fd_sc_hd__fill_2_453 VSS VDD VDD sky130_fd_sc_hd__fill_2
* cell instance sky130_fd_sc_hd__fill_2_454 r0 *1 0,0
Xsky130_fd_sc_hd__fill_2_454 VSS VDD VDD sky130_fd_sc_hd__fill_2
* cell instance sky130_fd_sc_hd__fill_2_455 r0 *1 0,0
Xsky130_fd_sc_hd__fill_2_455 VSS VDD VDD sky130_fd_sc_hd__fill_2
* cell instance sky130_fd_sc_hd__fill_2_456 r0 *1 0,0
Xsky130_fd_sc_hd__fill_2_456 VSS VDD VDD sky130_fd_sc_hd__fill_2
* cell instance sky130_fd_sc_hd__fill_2_457 r0 *1 0,0
Xsky130_fd_sc_hd__fill_2_457 VSS VDD VDD sky130_fd_sc_hd__fill_2
* cell instance sky130_fd_sc_hd__fill_2_458 r0 *1 0,0
Xsky130_fd_sc_hd__fill_2_458 VSS VDD VDD sky130_fd_sc_hd__fill_2
* cell instance sky130_fd_sc_hd__fill_2_459 r0 *1 0,0
Xsky130_fd_sc_hd__fill_2_459 VSS VDD VDD sky130_fd_sc_hd__fill_2
* cell instance sky130_fd_sc_hd__fill_2_460 r0 *1 0,0
Xsky130_fd_sc_hd__fill_2_460 VSS VDD VDD sky130_fd_sc_hd__fill_2
* cell instance sky130_fd_sc_hd__fill_2_461 r0 *1 0,0
Xsky130_fd_sc_hd__fill_2_461 VSS VDD VDD sky130_fd_sc_hd__fill_2
* cell instance sky130_fd_sc_hd__fill_2_462 r0 *1 0,0
Xsky130_fd_sc_hd__fill_2_462 VSS VDD VDD sky130_fd_sc_hd__fill_2
* cell instance sky130_fd_sc_hd__fill_2_463 r0 *1 0,0
Xsky130_fd_sc_hd__fill_2_463 VSS VDD VDD sky130_fd_sc_hd__fill_2
* cell instance sky130_fd_sc_hd__fill_2_464 r0 *1 0,0
Xsky130_fd_sc_hd__fill_2_464 VSS VDD VDD sky130_fd_sc_hd__fill_2
* cell instance sky130_fd_sc_hd__fill_2_465 r0 *1 0,0
Xsky130_fd_sc_hd__fill_2_465 VSS VDD VDD sky130_fd_sc_hd__fill_2
* cell instance sky130_fd_sc_hd__fill_2_466 r0 *1 0,0
Xsky130_fd_sc_hd__fill_2_466 VSS VDD VDD sky130_fd_sc_hd__fill_2
* cell instance sky130_fd_sc_hd__fill_2_467 r0 *1 0,0
Xsky130_fd_sc_hd__fill_2_467 VSS VDD VDD sky130_fd_sc_hd__fill_2
* cell instance sky130_fd_sc_hd__fill_2_468 r0 *1 0,0
Xsky130_fd_sc_hd__fill_2_468 VSS VDD VDD sky130_fd_sc_hd__fill_2
* cell instance sky130_fd_sc_hd__fill_2_469 r0 *1 0,0
Xsky130_fd_sc_hd__fill_2_469 VSS VDD VDD sky130_fd_sc_hd__fill_2
* cell instance sky130_fd_sc_hd__fill_2_470 r0 *1 0,0
Xsky130_fd_sc_hd__fill_2_470 VSS VDD VDD sky130_fd_sc_hd__fill_2
* cell instance sky130_fd_sc_hd__fill_2_471 r0 *1 0,0
Xsky130_fd_sc_hd__fill_2_471 VSS VDD VDD sky130_fd_sc_hd__fill_2
* cell instance sky130_fd_sc_hd__fill_2_472 r0 *1 0,0
Xsky130_fd_sc_hd__fill_2_472 VSS VDD VDD sky130_fd_sc_hd__fill_2
* cell instance sky130_fd_sc_hd__fill_2_473 r0 *1 0,0
Xsky130_fd_sc_hd__fill_2_473 VSS VDD VDD sky130_fd_sc_hd__fill_2
* cell instance sky130_fd_sc_hd__fill_2_474 r0 *1 0,0
Xsky130_fd_sc_hd__fill_2_474 VSS VDD VDD sky130_fd_sc_hd__fill_2
* cell instance sky130_fd_sc_hd__fill_2_475 r0 *1 0,0
Xsky130_fd_sc_hd__fill_2_475 VSS VDD VDD sky130_fd_sc_hd__fill_2
* cell instance sky130_fd_sc_hd__fill_2_476 r0 *1 0,0
Xsky130_fd_sc_hd__fill_2_476 VSS VDD VDD sky130_fd_sc_hd__fill_2
* cell instance sky130_fd_sc_hd__fill_2_477 r0 *1 0,0
Xsky130_fd_sc_hd__fill_2_477 VSS VDD VDD sky130_fd_sc_hd__fill_2
* cell instance sky130_fd_sc_hd__fill_2_478 r0 *1 0,0
Xsky130_fd_sc_hd__fill_2_478 VSS VDD VDD sky130_fd_sc_hd__fill_2
* cell instance sky130_fd_sc_hd__fill_2_479 r0 *1 0,0
Xsky130_fd_sc_hd__fill_2_479 VSS VDD VDD sky130_fd_sc_hd__fill_2
* cell instance sky130_fd_sc_hd__fill_2_480 r0 *1 0,0
Xsky130_fd_sc_hd__fill_2_480 VSS VDD VDD sky130_fd_sc_hd__fill_2
* cell instance sky130_fd_sc_hd__fill_2_481 r0 *1 0,0
Xsky130_fd_sc_hd__fill_2_481 VSS VDD VDD sky130_fd_sc_hd__fill_2
* cell instance sky130_fd_sc_hd__fill_2_482 r0 *1 0,0
Xsky130_fd_sc_hd__fill_2_482 VSS VDD VDD sky130_fd_sc_hd__fill_2
* cell instance sky130_fd_sc_hd__fill_2_483 r0 *1 0,0
Xsky130_fd_sc_hd__fill_2_483 VSS VDD VDD sky130_fd_sc_hd__fill_2
* cell instance sky130_fd_sc_hd__fill_2_484 r0 *1 0,0
Xsky130_fd_sc_hd__fill_2_484 VSS VDD VDD sky130_fd_sc_hd__fill_2
* cell instance sky130_fd_sc_hd__fill_2_485 r0 *1 0,0
Xsky130_fd_sc_hd__fill_2_485 VSS VDD VDD sky130_fd_sc_hd__fill_2
* cell instance sky130_fd_sc_hd__fill_2_486 r0 *1 0,0
Xsky130_fd_sc_hd__fill_2_486 VSS VDD VDD sky130_fd_sc_hd__fill_2
* cell instance sky130_fd_sc_hd__fill_2_487 r0 *1 0,0
Xsky130_fd_sc_hd__fill_2_487 VSS VDD VDD sky130_fd_sc_hd__fill_2
* cell instance sky130_fd_sc_hd__fill_2_488 r0 *1 0,0
Xsky130_fd_sc_hd__fill_2_488 VSS VDD VDD sky130_fd_sc_hd__fill_2
* cell instance sky130_fd_sc_hd__fill_2_489 r0 *1 0,0
Xsky130_fd_sc_hd__fill_2_489 VSS VDD VDD sky130_fd_sc_hd__fill_2
* cell instance sky130_fd_sc_hd__fill_2_490 r0 *1 0,0
Xsky130_fd_sc_hd__fill_2_490 VSS VDD VDD sky130_fd_sc_hd__fill_2
* cell instance sky130_fd_sc_hd__fill_2_491 r0 *1 0,0
Xsky130_fd_sc_hd__fill_2_491 VSS VDD VDD sky130_fd_sc_hd__fill_2
* cell instance sky130_fd_sc_hd__fill_2_492 r0 *1 0,0
Xsky130_fd_sc_hd__fill_2_492 VSS VDD VDD sky130_fd_sc_hd__fill_2
* cell instance sky130_fd_sc_hd__fill_2_493 r0 *1 0,0
Xsky130_fd_sc_hd__fill_2_493 VSS VDD VDD sky130_fd_sc_hd__fill_2
* cell instance sky130_fd_sc_hd__fill_2_494 r0 *1 0,0
Xsky130_fd_sc_hd__fill_2_494 VSS VDD VDD sky130_fd_sc_hd__fill_2
* cell instance sky130_fd_sc_hd__fill_2_495 r0 *1 0,0
Xsky130_fd_sc_hd__fill_2_495 VSS VDD VDD sky130_fd_sc_hd__fill_2
* cell instance sky130_fd_sc_hd__fill_2_496 r0 *1 0,0
Xsky130_fd_sc_hd__fill_2_496 VSS VDD VDD sky130_fd_sc_hd__fill_2
* cell instance sky130_fd_sc_hd__fill_2_497 r0 *1 0,0
Xsky130_fd_sc_hd__fill_2_497 VSS VDD VDD sky130_fd_sc_hd__fill_2
* cell instance sky130_fd_sc_hd__fill_2_498 r0 *1 0,0
Xsky130_fd_sc_hd__fill_2_498 VSS VDD VDD sky130_fd_sc_hd__fill_2
* cell instance sky130_fd_sc_hd__fill_2_499 r0 *1 0,0
Xsky130_fd_sc_hd__fill_2_499 VSS VDD VDD sky130_fd_sc_hd__fill_2
* cell instance sky130_fd_sc_hd__fill_2_500 r0 *1 0,0
Xsky130_fd_sc_hd__fill_2_500 VSS VDD VDD sky130_fd_sc_hd__fill_2
* cell instance sky130_fd_sc_hd__fill_2_501 r0 *1 0,0
Xsky130_fd_sc_hd__fill_2_501 VSS VDD VDD sky130_fd_sc_hd__fill_2
* cell instance sky130_fd_sc_hd__fill_2_502 r0 *1 0,0
Xsky130_fd_sc_hd__fill_2_502 VSS VDD VDD sky130_fd_sc_hd__fill_2
* cell instance sky130_fd_sc_hd__fill_2_503 r0 *1 0,0
Xsky130_fd_sc_hd__fill_2_503 VSS VDD VDD sky130_fd_sc_hd__fill_2
* cell instance sky130_fd_sc_hd__fill_2_504 r0 *1 0,0
Xsky130_fd_sc_hd__fill_2_504 VSS VDD VDD sky130_fd_sc_hd__fill_2
* cell instance sky130_fd_sc_hd__fill_2_505 r0 *1 0,0
Xsky130_fd_sc_hd__fill_2_505 VSS VDD VDD sky130_fd_sc_hd__fill_2
* cell instance sky130_fd_sc_hd__fill_2_506 r0 *1 0,0
Xsky130_fd_sc_hd__fill_2_506 VSS VDD VDD sky130_fd_sc_hd__fill_2
* cell instance sky130_fd_sc_hd__fill_2_507 r0 *1 0,0
Xsky130_fd_sc_hd__fill_2_507 VSS VDD VDD sky130_fd_sc_hd__fill_2
* cell instance sky130_fd_sc_hd__fill_2_508 r0 *1 0,0
Xsky130_fd_sc_hd__fill_2_508 VSS VDD VDD sky130_fd_sc_hd__fill_2
* cell instance sky130_fd_sc_hd__fill_2_509 r0 *1 0,0
Xsky130_fd_sc_hd__fill_2_509 VSS VDD VDD sky130_fd_sc_hd__fill_2
* cell instance sky130_fd_sc_hd__fill_2_510 r0 *1 0,0
Xsky130_fd_sc_hd__fill_2_510 VSS VDD VDD sky130_fd_sc_hd__fill_2
* cell instance sky130_fd_sc_hd__fill_2_511 r0 *1 0,0
Xsky130_fd_sc_hd__fill_2_511 VSS VDD VDD sky130_fd_sc_hd__fill_2
* cell instance sky130_fd_sc_hd__fill_2_512 r0 *1 0,0
Xsky130_fd_sc_hd__fill_2_512 VSS VDD VDD sky130_fd_sc_hd__fill_2
* cell instance sky130_fd_sc_hd__fill_2_513 r0 *1 0,0
Xsky130_fd_sc_hd__fill_2_513 VSS VDD VDD sky130_fd_sc_hd__fill_2
* cell instance sky130_fd_sc_hd__fill_2_514 r0 *1 0,0
Xsky130_fd_sc_hd__fill_2_514 VSS VDD VDD sky130_fd_sc_hd__fill_2
* cell instance sky130_fd_sc_hd__fill_2_515 r0 *1 0,0
Xsky130_fd_sc_hd__fill_2_515 VSS VDD VDD sky130_fd_sc_hd__fill_2
* cell instance sky130_fd_sc_hd__fill_2_516 r0 *1 0,0
Xsky130_fd_sc_hd__fill_2_516 VSS VDD VDD sky130_fd_sc_hd__fill_2
* cell instance sky130_fd_sc_hd__fill_2_517 r0 *1 0,0
Xsky130_fd_sc_hd__fill_2_517 VSS VDD VDD sky130_fd_sc_hd__fill_2
* cell instance sky130_fd_sc_hd__fill_2_518 r0 *1 0,0
Xsky130_fd_sc_hd__fill_2_518 VSS VDD VDD sky130_fd_sc_hd__fill_2
* cell instance sky130_fd_sc_hd__fill_2_519 r0 *1 0,0
Xsky130_fd_sc_hd__fill_2_519 VSS VDD VDD sky130_fd_sc_hd__fill_2
* cell instance sky130_fd_sc_hd__fill_2_520 r0 *1 0,0
Xsky130_fd_sc_hd__fill_2_520 VSS VDD VDD sky130_fd_sc_hd__fill_2
* cell instance sky130_fd_sc_hd__fill_2_521 r0 *1 0,0
Xsky130_fd_sc_hd__fill_2_521 VSS VDD VDD sky130_fd_sc_hd__fill_2
* cell instance sky130_fd_sc_hd__fill_2_522 r0 *1 0,0
Xsky130_fd_sc_hd__fill_2_522 VSS VDD VDD sky130_fd_sc_hd__fill_2
* cell instance sky130_fd_sc_hd__fill_2_523 r0 *1 0,0
Xsky130_fd_sc_hd__fill_2_523 VSS VDD VDD sky130_fd_sc_hd__fill_2
* cell instance sky130_fd_sc_hd__fill_2_524 r0 *1 0,0
Xsky130_fd_sc_hd__fill_2_524 VSS VDD VDD sky130_fd_sc_hd__fill_2
* cell instance sky130_fd_sc_hd__fill_2_525 r0 *1 0,0
Xsky130_fd_sc_hd__fill_2_525 VSS VDD VDD sky130_fd_sc_hd__fill_2
* cell instance sky130_fd_sc_hd__fill_2_526 r0 *1 0,0
Xsky130_fd_sc_hd__fill_2_526 VSS VDD VDD sky130_fd_sc_hd__fill_2
* cell instance sky130_fd_sc_hd__fill_2_527 r0 *1 0,0
Xsky130_fd_sc_hd__fill_2_527 VSS VDD VDD sky130_fd_sc_hd__fill_2
* cell instance sky130_fd_sc_hd__fill_2_528 r0 *1 0,0
Xsky130_fd_sc_hd__fill_2_528 VSS VDD VDD sky130_fd_sc_hd__fill_2
* cell instance sky130_fd_sc_hd__fill_2_529 r0 *1 0,0
Xsky130_fd_sc_hd__fill_2_529 VSS VDD VDD sky130_fd_sc_hd__fill_2
* cell instance sky130_fd_sc_hd__fill_2_530 r0 *1 0,0
Xsky130_fd_sc_hd__fill_2_530 VSS VDD VDD sky130_fd_sc_hd__fill_2
* cell instance sky130_fd_sc_hd__fill_2_531 r0 *1 0,0
Xsky130_fd_sc_hd__fill_2_531 VSS VDD VDD sky130_fd_sc_hd__fill_2
* cell instance sky130_fd_sc_hd__fill_2_532 r0 *1 0,0
Xsky130_fd_sc_hd__fill_2_532 VSS VDD VDD sky130_fd_sc_hd__fill_2
* cell instance sky130_fd_sc_hd__fill_2_533 r0 *1 0,0
Xsky130_fd_sc_hd__fill_2_533 VSS VDD VDD sky130_fd_sc_hd__fill_2
* cell instance sky130_fd_sc_hd__fill_2_534 r0 *1 0,0
Xsky130_fd_sc_hd__fill_2_534 VSS VDD VDD sky130_fd_sc_hd__fill_2
* cell instance sky130_fd_sc_hd__fill_2_535 r0 *1 0,0
Xsky130_fd_sc_hd__fill_2_535 VSS VDD VDD sky130_fd_sc_hd__fill_2
* cell instance sky130_fd_sc_hd__fill_2_536 r0 *1 0,0
Xsky130_fd_sc_hd__fill_2_536 VSS VDD VDD sky130_fd_sc_hd__fill_2
* cell instance sky130_fd_sc_hd__fill_2_537 r0 *1 0,0
Xsky130_fd_sc_hd__fill_2_537 VSS VDD VDD sky130_fd_sc_hd__fill_2
* cell instance sky130_fd_sc_hd__fill_2_538 r0 *1 0,0
Xsky130_fd_sc_hd__fill_2_538 VSS VDD VDD sky130_fd_sc_hd__fill_2
* cell instance sky130_fd_sc_hd__fill_2_539 r0 *1 0,0
Xsky130_fd_sc_hd__fill_2_539 VSS VDD VDD sky130_fd_sc_hd__fill_2
* cell instance sky130_fd_sc_hd__fill_2_540 r0 *1 0,0
Xsky130_fd_sc_hd__fill_2_540 VSS VDD VDD sky130_fd_sc_hd__fill_2
* cell instance sky130_fd_sc_hd__fill_2_541 r0 *1 0,0
Xsky130_fd_sc_hd__fill_2_541 VSS VDD VDD sky130_fd_sc_hd__fill_2
* cell instance sky130_fd_sc_hd__fill_2_542 r0 *1 0,0
Xsky130_fd_sc_hd__fill_2_542 VSS VDD VDD sky130_fd_sc_hd__fill_2
* cell instance sky130_fd_sc_hd__fill_2_543 r0 *1 0,0
Xsky130_fd_sc_hd__fill_2_543 VSS VDD VDD sky130_fd_sc_hd__fill_2
* cell instance sky130_fd_sc_hd__fill_2_544 r0 *1 0,0
Xsky130_fd_sc_hd__fill_2_544 VSS VDD VDD sky130_fd_sc_hd__fill_2
* cell instance sky130_fd_sc_hd__fill_2_545 r0 *1 0,0
Xsky130_fd_sc_hd__fill_2_545 VSS VDD VDD sky130_fd_sc_hd__fill_2
* cell instance sky130_fd_sc_hd__fill_2_546 r0 *1 0,0
Xsky130_fd_sc_hd__fill_2_546 VSS VDD VDD sky130_fd_sc_hd__fill_2
* cell instance sky130_fd_sc_hd__fill_2_547 r0 *1 0,0
Xsky130_fd_sc_hd__fill_2_547 VSS VDD VDD sky130_fd_sc_hd__fill_2
* cell instance sky130_fd_sc_hd__fill_2_548 r0 *1 0,0
Xsky130_fd_sc_hd__fill_2_548 VSS VDD VDD sky130_fd_sc_hd__fill_2
* cell instance sky130_fd_sc_hd__fill_2_549 r0 *1 0,0
Xsky130_fd_sc_hd__fill_2_549 VSS VDD VDD sky130_fd_sc_hd__fill_2
* cell instance sky130_fd_sc_hd__fill_2_550 r0 *1 0,0
Xsky130_fd_sc_hd__fill_2_550 VSS VDD VDD sky130_fd_sc_hd__fill_2
* cell instance sky130_fd_sc_hd__fill_2_551 r0 *1 0,0
Xsky130_fd_sc_hd__fill_2_551 VSS VDD VDD sky130_fd_sc_hd__fill_2
* cell instance sky130_fd_sc_hd__fill_2_552 r0 *1 0,0
Xsky130_fd_sc_hd__fill_2_552 VSS VDD VDD sky130_fd_sc_hd__fill_2
* cell instance sky130_fd_sc_hd__fill_2_553 r0 *1 0,0
Xsky130_fd_sc_hd__fill_2_553 VSS VDD VDD sky130_fd_sc_hd__fill_2
* cell instance sky130_fd_sc_hd__fill_2_554 r0 *1 0,0
Xsky130_fd_sc_hd__fill_2_554 VSS VDD VDD sky130_fd_sc_hd__fill_2
* cell instance sky130_fd_sc_hd__fill_2_555 r0 *1 0,0
Xsky130_fd_sc_hd__fill_2_555 VSS VDD VDD sky130_fd_sc_hd__fill_2
* cell instance sky130_fd_sc_hd__fill_2_556 r0 *1 0,0
Xsky130_fd_sc_hd__fill_2_556 VSS VDD VDD sky130_fd_sc_hd__fill_2
* cell instance sky130_fd_sc_hd__fill_2_557 r0 *1 0,0
Xsky130_fd_sc_hd__fill_2_557 VSS VDD VDD sky130_fd_sc_hd__fill_2
* cell instance sky130_fd_sc_hd__fill_2_558 r0 *1 0,0
Xsky130_fd_sc_hd__fill_2_558 VSS VDD VDD sky130_fd_sc_hd__fill_2
* cell instance sky130_fd_sc_hd__fill_2_559 r0 *1 0,0
Xsky130_fd_sc_hd__fill_2_559 VSS VDD VDD sky130_fd_sc_hd__fill_2
* cell instance sky130_fd_sc_hd__fill_2_560 r0 *1 0,0
Xsky130_fd_sc_hd__fill_2_560 VSS VDD VDD sky130_fd_sc_hd__fill_2
* cell instance sky130_fd_sc_hd__fill_2_561 r0 *1 0,0
Xsky130_fd_sc_hd__fill_2_561 VSS VDD VDD sky130_fd_sc_hd__fill_2
* cell instance sky130_fd_sc_hd__fill_2_562 r0 *1 0,0
Xsky130_fd_sc_hd__fill_2_562 VSS VDD VDD sky130_fd_sc_hd__fill_2
* cell instance sky130_fd_sc_hd__fill_2_563 r0 *1 0,0
Xsky130_fd_sc_hd__fill_2_563 VSS VDD VDD sky130_fd_sc_hd__fill_2
* cell instance sky130_fd_sc_hd__fill_2_564 r0 *1 0,0
Xsky130_fd_sc_hd__fill_2_564 VSS VDD VDD sky130_fd_sc_hd__fill_2
* cell instance sky130_fd_sc_hd__fill_2_565 r0 *1 0,0
Xsky130_fd_sc_hd__fill_2_565 VSS VDD VDD sky130_fd_sc_hd__fill_2
* cell instance sky130_fd_sc_hd__fill_2_566 r0 *1 0,0
Xsky130_fd_sc_hd__fill_2_566 VSS VDD VDD sky130_fd_sc_hd__fill_2
* cell instance sky130_fd_sc_hd__fill_2_567 r0 *1 0,0
Xsky130_fd_sc_hd__fill_2_567 VSS VDD VDD sky130_fd_sc_hd__fill_2
* cell instance sky130_fd_sc_hd__fill_2_568 r0 *1 0,0
Xsky130_fd_sc_hd__fill_2_568 VSS VDD VDD sky130_fd_sc_hd__fill_2
* cell instance sky130_fd_sc_hd__fill_2_569 r0 *1 0,0
Xsky130_fd_sc_hd__fill_2_569 VSS VDD VDD sky130_fd_sc_hd__fill_2
* cell instance sky130_fd_sc_hd__fill_2_570 r0 *1 0,0
Xsky130_fd_sc_hd__fill_2_570 VSS VDD VDD sky130_fd_sc_hd__fill_2
* cell instance sky130_fd_sc_hd__fill_2_571 r0 *1 0,0
Xsky130_fd_sc_hd__fill_2_571 VSS VDD VDD sky130_fd_sc_hd__fill_2
* cell instance sky130_fd_sc_hd__fill_2_572 r0 *1 0,0
Xsky130_fd_sc_hd__fill_2_572 VSS VDD VDD sky130_fd_sc_hd__fill_2
* cell instance sky130_fd_sc_hd__fill_2_573 r0 *1 0,0
Xsky130_fd_sc_hd__fill_2_573 VSS VDD VDD sky130_fd_sc_hd__fill_2
* cell instance sky130_fd_sc_hd__fill_2_574 r0 *1 0,0
Xsky130_fd_sc_hd__fill_2_574 VSS VDD VDD sky130_fd_sc_hd__fill_2
* cell instance sky130_fd_sc_hd__fill_2_575 r0 *1 0,0
Xsky130_fd_sc_hd__fill_2_575 VSS VDD VDD sky130_fd_sc_hd__fill_2
* cell instance sky130_fd_sc_hd__fill_2_576 r0 *1 0,0
Xsky130_fd_sc_hd__fill_2_576 VSS VDD VDD sky130_fd_sc_hd__fill_2
* cell instance sky130_fd_sc_hd__fill_2_577 r0 *1 0,0
Xsky130_fd_sc_hd__fill_2_577 VSS VDD VDD sky130_fd_sc_hd__fill_2
* cell instance sky130_fd_sc_hd__fill_2_578 r0 *1 0,0
Xsky130_fd_sc_hd__fill_2_578 VSS VDD VDD sky130_fd_sc_hd__fill_2
* cell instance sky130_fd_sc_hd__fill_2_579 r0 *1 0,0
Xsky130_fd_sc_hd__fill_2_579 VSS VDD VDD sky130_fd_sc_hd__fill_2
* cell instance sky130_fd_sc_hd__fill_2_580 r0 *1 0,0
Xsky130_fd_sc_hd__fill_2_580 VSS VDD VDD sky130_fd_sc_hd__fill_2
* cell instance sky130_fd_sc_hd__fill_2_581 r0 *1 0,0
Xsky130_fd_sc_hd__fill_2_581 VSS VDD VDD sky130_fd_sc_hd__fill_2
* cell instance sky130_fd_sc_hd__fill_2_582 r0 *1 0,0
Xsky130_fd_sc_hd__fill_2_582 VSS VDD VDD sky130_fd_sc_hd__fill_2
* cell instance sky130_fd_sc_hd__fill_2_583 r0 *1 0,0
Xsky130_fd_sc_hd__fill_2_583 VSS VDD VDD sky130_fd_sc_hd__fill_2
* cell instance sky130_fd_sc_hd__fill_2_584 r0 *1 0,0
Xsky130_fd_sc_hd__fill_2_584 VSS VDD VDD sky130_fd_sc_hd__fill_2
* cell instance sky130_fd_sc_hd__fill_2_585 r0 *1 0,0
Xsky130_fd_sc_hd__fill_2_585 VSS VDD VDD sky130_fd_sc_hd__fill_2
* cell instance sky130_fd_sc_hd__fill_2_586 r0 *1 0,0
Xsky130_fd_sc_hd__fill_2_586 VSS VDD VDD sky130_fd_sc_hd__fill_2
* cell instance sky130_fd_sc_hd__fill_2_587 r0 *1 0,0
Xsky130_fd_sc_hd__fill_2_587 VSS VDD VDD sky130_fd_sc_hd__fill_2
* cell instance sky130_fd_sc_hd__fill_2_588 r0 *1 0,0
Xsky130_fd_sc_hd__fill_2_588 VSS VDD VDD sky130_fd_sc_hd__fill_2
* cell instance sky130_fd_sc_hd__fill_2_589 r0 *1 0,0
Xsky130_fd_sc_hd__fill_2_589 VSS VDD VDD sky130_fd_sc_hd__fill_2
* cell instance sky130_fd_sc_hd__fill_2_590 r0 *1 0,0
Xsky130_fd_sc_hd__fill_2_590 VSS VDD VDD sky130_fd_sc_hd__fill_2
* cell instance sky130_fd_sc_hd__fill_2_591 r0 *1 0,0
Xsky130_fd_sc_hd__fill_2_591 VSS VDD VDD sky130_fd_sc_hd__fill_2
* cell instance sky130_fd_sc_hd__fill_2_592 r0 *1 0,0
Xsky130_fd_sc_hd__fill_2_592 VSS VDD VDD sky130_fd_sc_hd__fill_2
* cell instance sky130_fd_sc_hd__fill_2_593 r0 *1 0,0
Xsky130_fd_sc_hd__fill_2_593 VSS VDD VDD sky130_fd_sc_hd__fill_2
* cell instance sky130_fd_sc_hd__fill_2_594 r0 *1 0,0
Xsky130_fd_sc_hd__fill_2_594 VSS VDD VDD sky130_fd_sc_hd__fill_2
* cell instance sky130_fd_sc_hd__fill_2_595 r0 *1 0,0
Xsky130_fd_sc_hd__fill_2_595 VSS VDD VDD sky130_fd_sc_hd__fill_2
* cell instance sky130_fd_sc_hd__fill_2_596 r0 *1 0,0
Xsky130_fd_sc_hd__fill_2_596 VSS VDD VDD sky130_fd_sc_hd__fill_2
* cell instance sky130_fd_sc_hd__fill_2_597 r0 *1 0,0
Xsky130_fd_sc_hd__fill_2_597 VSS VDD VDD sky130_fd_sc_hd__fill_2
* cell instance sky130_fd_sc_hd__fill_2_598 r0 *1 0,0
Xsky130_fd_sc_hd__fill_2_598 VSS VDD VDD sky130_fd_sc_hd__fill_2
* cell instance sky130_fd_sc_hd__fill_2_599 r0 *1 0,0
Xsky130_fd_sc_hd__fill_2_599 VSS VDD VDD sky130_fd_sc_hd__fill_2
* cell instance sky130_fd_sc_hd__fill_2_600 r0 *1 0,0
Xsky130_fd_sc_hd__fill_2_600 VSS VDD VDD sky130_fd_sc_hd__fill_2
* cell instance sky130_fd_sc_hd__fill_2_601 r0 *1 0,0
Xsky130_fd_sc_hd__fill_2_601 VSS VDD VDD sky130_fd_sc_hd__fill_2
* cell instance sky130_fd_sc_hd__fill_2_602 r0 *1 0,0
Xsky130_fd_sc_hd__fill_2_602 VSS VDD VDD sky130_fd_sc_hd__fill_2
* cell instance sky130_fd_sc_hd__fill_2_603 r0 *1 0,0
Xsky130_fd_sc_hd__fill_2_603 VSS VDD VDD sky130_fd_sc_hd__fill_2
* cell instance sky130_fd_sc_hd__fill_2_604 r0 *1 0,0
Xsky130_fd_sc_hd__fill_2_604 VSS VDD VDD sky130_fd_sc_hd__fill_2
* cell instance sky130_fd_sc_hd__fill_2_605 r0 *1 0,0
Xsky130_fd_sc_hd__fill_2_605 VSS VDD VDD sky130_fd_sc_hd__fill_2
* cell instance sky130_fd_sc_hd__fill_2_606 r0 *1 0,0
Xsky130_fd_sc_hd__fill_2_606 VSS VDD VDD sky130_fd_sc_hd__fill_2
* cell instance sky130_fd_sc_hd__fill_2_607 r0 *1 0,0
Xsky130_fd_sc_hd__fill_2_607 VSS VDD VDD sky130_fd_sc_hd__fill_2
* cell instance sky130_fd_sc_hd__fill_2_608 r0 *1 0,0
Xsky130_fd_sc_hd__fill_2_608 VSS VDD VDD sky130_fd_sc_hd__fill_2
* cell instance sky130_fd_sc_hd__fill_2_609 r0 *1 0,0
Xsky130_fd_sc_hd__fill_2_609 VSS VDD VDD sky130_fd_sc_hd__fill_2
* cell instance sky130_fd_sc_hd__fill_2_610 r0 *1 0,0
Xsky130_fd_sc_hd__fill_2_610 VSS VDD VDD sky130_fd_sc_hd__fill_2
* cell instance sky130_fd_sc_hd__fill_2_611 r0 *1 0,0
Xsky130_fd_sc_hd__fill_2_611 VSS VDD VDD sky130_fd_sc_hd__fill_2
* cell instance sky130_fd_sc_hd__fill_2_612 r0 *1 0,0
Xsky130_fd_sc_hd__fill_2_612 VSS VDD VDD sky130_fd_sc_hd__fill_2
* cell instance sky130_fd_sc_hd__fill_2_613 r0 *1 0,0
Xsky130_fd_sc_hd__fill_2_613 VSS VDD VDD sky130_fd_sc_hd__fill_2
* cell instance sky130_fd_sc_hd__fill_2_614 r0 *1 0,0
Xsky130_fd_sc_hd__fill_2_614 VSS VDD VDD sky130_fd_sc_hd__fill_2
* cell instance sky130_fd_sc_hd__fill_2_615 r0 *1 0,0
Xsky130_fd_sc_hd__fill_2_615 VSS VDD VDD sky130_fd_sc_hd__fill_2
* cell instance sky130_fd_sc_hd__fill_2_616 r0 *1 0,0
Xsky130_fd_sc_hd__fill_2_616 VSS VDD VDD sky130_fd_sc_hd__fill_2
* cell instance sky130_fd_sc_hd__fill_2_617 r0 *1 0,0
Xsky130_fd_sc_hd__fill_2_617 VSS VDD VDD sky130_fd_sc_hd__fill_2
* cell instance sky130_fd_sc_hd__fill_2_618 r0 *1 0,0
Xsky130_fd_sc_hd__fill_2_618 VSS VDD VDD sky130_fd_sc_hd__fill_2
* cell instance sky130_fd_sc_hd__fill_2_619 r0 *1 0,0
Xsky130_fd_sc_hd__fill_2_619 VSS VDD VDD sky130_fd_sc_hd__fill_2
* cell instance sky130_fd_sc_hd__fill_2_620 r0 *1 0,0
Xsky130_fd_sc_hd__fill_2_620 VSS VDD VDD sky130_fd_sc_hd__fill_2
* cell instance sky130_fd_sc_hd__fill_2_621 r0 *1 0,0
Xsky130_fd_sc_hd__fill_2_621 VSS VDD VDD sky130_fd_sc_hd__fill_2
* cell instance sky130_fd_sc_hd__fill_2_622 r0 *1 0,0
Xsky130_fd_sc_hd__fill_2_622 VSS VDD VDD sky130_fd_sc_hd__fill_2
* cell instance sky130_fd_sc_hd__fill_2_623 r0 *1 0,0
Xsky130_fd_sc_hd__fill_2_623 VSS VDD VDD sky130_fd_sc_hd__fill_2
* cell instance sky130_fd_sc_hd__fill_2_624 r0 *1 0,0
Xsky130_fd_sc_hd__fill_2_624 VSS VDD VDD sky130_fd_sc_hd__fill_2
* cell instance sky130_fd_sc_hd__fill_2_625 r0 *1 0,0
Xsky130_fd_sc_hd__fill_2_625 VSS VDD VDD sky130_fd_sc_hd__fill_2
* cell instance sky130_fd_sc_hd__fill_2_626 r0 *1 0,0
Xsky130_fd_sc_hd__fill_2_626 VSS VDD VDD sky130_fd_sc_hd__fill_2
* cell instance sky130_fd_sc_hd__fill_2_627 r0 *1 0,0
Xsky130_fd_sc_hd__fill_2_627 VSS VDD VDD sky130_fd_sc_hd__fill_2
* cell instance sky130_fd_sc_hd__fill_2_628 r0 *1 0,0
Xsky130_fd_sc_hd__fill_2_628 VSS VDD VDD sky130_fd_sc_hd__fill_2
* cell instance sky130_fd_sc_hd__fill_2_629 r0 *1 0,0
Xsky130_fd_sc_hd__fill_2_629 VSS VDD VDD sky130_fd_sc_hd__fill_2
* cell instance sky130_fd_sc_hd__fill_2_630 r0 *1 0,0
Xsky130_fd_sc_hd__fill_2_630 VSS VDD VDD sky130_fd_sc_hd__fill_2
* cell instance sky130_fd_sc_hd__fill_2_631 r0 *1 0,0
Xsky130_fd_sc_hd__fill_2_631 VSS VDD VDD sky130_fd_sc_hd__fill_2
* cell instance sky130_fd_sc_hd__fill_2_632 r0 *1 0,0
Xsky130_fd_sc_hd__fill_2_632 VSS VDD VDD sky130_fd_sc_hd__fill_2
* cell instance sky130_fd_sc_hd__fill_2_633 r0 *1 0,0
Xsky130_fd_sc_hd__fill_2_633 VSS VDD VDD sky130_fd_sc_hd__fill_2
* cell instance sky130_fd_sc_hd__fill_2_634 r0 *1 0,0
Xsky130_fd_sc_hd__fill_2_634 VSS VDD VDD sky130_fd_sc_hd__fill_2
* cell instance sky130_fd_sc_hd__fill_2_635 r0 *1 0,0
Xsky130_fd_sc_hd__fill_2_635 VSS VDD VDD sky130_fd_sc_hd__fill_2
* cell instance sky130_fd_sc_hd__fill_2_636 r0 *1 0,0
Xsky130_fd_sc_hd__fill_2_636 VSS VDD VDD sky130_fd_sc_hd__fill_2
* cell instance sky130_fd_sc_hd__fill_2_637 r0 *1 0,0
Xsky130_fd_sc_hd__fill_2_637 VSS VDD VDD sky130_fd_sc_hd__fill_2
* cell instance sky130_fd_sc_hd__fill_2_638 r0 *1 0,0
Xsky130_fd_sc_hd__fill_2_638 VSS VDD VDD sky130_fd_sc_hd__fill_2
* cell instance sky130_fd_sc_hd__fill_2_639 r0 *1 0,0
Xsky130_fd_sc_hd__fill_2_639 VSS VDD VDD sky130_fd_sc_hd__fill_2
* cell instance sky130_fd_sc_hd__fill_2_640 r0 *1 0,0
Xsky130_fd_sc_hd__fill_2_640 VSS VDD VDD sky130_fd_sc_hd__fill_2
* cell instance sky130_fd_sc_hd__fill_2_641 r0 *1 0,0
Xsky130_fd_sc_hd__fill_2_641 VSS VDD VDD sky130_fd_sc_hd__fill_2
* cell instance sky130_fd_sc_hd__fill_2_642 r0 *1 0,0
Xsky130_fd_sc_hd__fill_2_642 VSS VDD VDD sky130_fd_sc_hd__fill_2
* cell instance sky130_fd_sc_hd__fill_2_643 r0 *1 0,0
Xsky130_fd_sc_hd__fill_2_643 VSS VDD VDD sky130_fd_sc_hd__fill_2
* cell instance sky130_fd_sc_hd__fill_2_644 r0 *1 0,0
Xsky130_fd_sc_hd__fill_2_644 VSS VDD VDD sky130_fd_sc_hd__fill_2
* cell instance sky130_fd_sc_hd__fill_2_645 r0 *1 0,0
Xsky130_fd_sc_hd__fill_2_645 VSS VDD VDD sky130_fd_sc_hd__fill_2
* cell instance sky130_fd_sc_hd__fill_2_646 r0 *1 0,0
Xsky130_fd_sc_hd__fill_2_646 VSS VDD VDD sky130_fd_sc_hd__fill_2
* cell instance sky130_fd_sc_hd__fill_2_647 r0 *1 0,0
Xsky130_fd_sc_hd__fill_2_647 VSS VDD VDD sky130_fd_sc_hd__fill_2
* cell instance sky130_fd_sc_hd__fill_2_648 r0 *1 0,0
Xsky130_fd_sc_hd__fill_2_648 VSS VDD VDD sky130_fd_sc_hd__fill_2
* cell instance sky130_fd_sc_hd__fill_2_649 r0 *1 0,0
Xsky130_fd_sc_hd__fill_2_649 VSS VDD VDD sky130_fd_sc_hd__fill_2
* cell instance sky130_fd_sc_hd__fill_2_650 r0 *1 0,0
Xsky130_fd_sc_hd__fill_2_650 VSS VDD VDD sky130_fd_sc_hd__fill_2
* cell instance sky130_fd_sc_hd__fill_2_651 r0 *1 0,0
Xsky130_fd_sc_hd__fill_2_651 VSS VDD VDD sky130_fd_sc_hd__fill_2
* cell instance sky130_fd_sc_hd__fill_2_652 r0 *1 0,0
Xsky130_fd_sc_hd__fill_2_652 VSS VDD VDD sky130_fd_sc_hd__fill_2
* cell instance sky130_fd_sc_hd__fill_2_653 r0 *1 0,0
Xsky130_fd_sc_hd__fill_2_653 VSS VDD VDD sky130_fd_sc_hd__fill_2
* cell instance sky130_fd_sc_hd__fill_2_654 r0 *1 0,0
Xsky130_fd_sc_hd__fill_2_654 VSS VDD VDD sky130_fd_sc_hd__fill_2
* cell instance sky130_fd_sc_hd__fill_2_655 r0 *1 0,0
Xsky130_fd_sc_hd__fill_2_655 VSS VDD VDD sky130_fd_sc_hd__fill_2
* cell instance sky130_fd_sc_hd__fill_2_656 r0 *1 0,0
Xsky130_fd_sc_hd__fill_2_656 VSS VDD VDD sky130_fd_sc_hd__fill_2
* cell instance sky130_fd_sc_hd__fill_2_657 r0 *1 0,0
Xsky130_fd_sc_hd__fill_2_657 VSS VDD VDD sky130_fd_sc_hd__fill_2
* cell instance sky130_fd_sc_hd__fill_2_658 r0 *1 0,0
Xsky130_fd_sc_hd__fill_2_658 VSS VDD VDD sky130_fd_sc_hd__fill_2
* cell instance sky130_fd_sc_hd__fill_2_659 r0 *1 0,0
Xsky130_fd_sc_hd__fill_2_659 VSS VDD VDD sky130_fd_sc_hd__fill_2
* cell instance sky130_fd_sc_hd__fill_2_660 r0 *1 0,0
Xsky130_fd_sc_hd__fill_2_660 VSS VDD VDD sky130_fd_sc_hd__fill_2
* cell instance sky130_fd_sc_hd__fill_2_661 r0 *1 0,0
Xsky130_fd_sc_hd__fill_2_661 VSS VDD VDD sky130_fd_sc_hd__fill_2
* cell instance sky130_fd_sc_hd__fill_2_662 r0 *1 0,0
Xsky130_fd_sc_hd__fill_2_662 VSS VDD VDD sky130_fd_sc_hd__fill_2
* cell instance sky130_fd_sc_hd__fill_2_663 r0 *1 0,0
Xsky130_fd_sc_hd__fill_2_663 VSS VDD VDD sky130_fd_sc_hd__fill_2
* cell instance sky130_fd_sc_hd__fill_2_664 r0 *1 0,0
Xsky130_fd_sc_hd__fill_2_664 VSS VDD VDD sky130_fd_sc_hd__fill_2
* cell instance sky130_fd_sc_hd__fill_2_665 r0 *1 0,0
Xsky130_fd_sc_hd__fill_2_665 VSS VDD VDD sky130_fd_sc_hd__fill_2
* cell instance sky130_fd_sc_hd__fill_2_666 r0 *1 0,0
Xsky130_fd_sc_hd__fill_2_666 VSS VDD VDD sky130_fd_sc_hd__fill_2
* cell instance sky130_fd_sc_hd__fill_2_667 r0 *1 0,0
Xsky130_fd_sc_hd__fill_2_667 VSS VDD VDD sky130_fd_sc_hd__fill_2
* cell instance sky130_fd_sc_hd__fill_2_668 r0 *1 0,0
Xsky130_fd_sc_hd__fill_2_668 VSS VDD VDD sky130_fd_sc_hd__fill_2
* cell instance sky130_fd_sc_hd__fill_2_669 r0 *1 0,0
Xsky130_fd_sc_hd__fill_2_669 VSS VDD VDD sky130_fd_sc_hd__fill_2
* cell instance sky130_fd_sc_hd__fill_2_670 r0 *1 0,0
Xsky130_fd_sc_hd__fill_2_670 VSS VDD VDD sky130_fd_sc_hd__fill_2
* cell instance sky130_fd_sc_hd__fill_2_671 r0 *1 0,0
Xsky130_fd_sc_hd__fill_2_671 VSS VDD VDD sky130_fd_sc_hd__fill_2
* cell instance sky130_fd_sc_hd__fill_2_672 r0 *1 0,0
Xsky130_fd_sc_hd__fill_2_672 VSS VDD VDD sky130_fd_sc_hd__fill_2
* cell instance sky130_fd_sc_hd__fill_2_673 r0 *1 0,0
Xsky130_fd_sc_hd__fill_2_673 VSS VDD VDD sky130_fd_sc_hd__fill_2
* cell instance sky130_fd_sc_hd__fill_2_674 r0 *1 0,0
Xsky130_fd_sc_hd__fill_2_674 VSS VDD VDD sky130_fd_sc_hd__fill_2
* cell instance sky130_fd_sc_hd__fill_2_675 r0 *1 0,0
Xsky130_fd_sc_hd__fill_2_675 VSS VDD VDD sky130_fd_sc_hd__fill_2
* cell instance sky130_fd_sc_hd__fill_2_676 r0 *1 0,0
Xsky130_fd_sc_hd__fill_2_676 VSS VDD VDD sky130_fd_sc_hd__fill_2
* cell instance sky130_fd_sc_hd__fill_2_677 r0 *1 0,0
Xsky130_fd_sc_hd__fill_2_677 VSS VDD VDD sky130_fd_sc_hd__fill_2
* cell instance sky130_fd_sc_hd__fill_2_678 r0 *1 0,0
Xsky130_fd_sc_hd__fill_2_678 VSS VDD VDD sky130_fd_sc_hd__fill_2
* cell instance sky130_fd_sc_hd__fill_2_679 r0 *1 0,0
Xsky130_fd_sc_hd__fill_2_679 VSS VDD VDD sky130_fd_sc_hd__fill_2
* cell instance sky130_fd_sc_hd__fill_2_680 r0 *1 0,0
Xsky130_fd_sc_hd__fill_2_680 VSS VDD VDD sky130_fd_sc_hd__fill_2
* cell instance sky130_fd_sc_hd__fill_2_681 r0 *1 0,0
Xsky130_fd_sc_hd__fill_2_681 VSS VDD VDD sky130_fd_sc_hd__fill_2
* cell instance sky130_fd_sc_hd__fill_2_682 r0 *1 0,0
Xsky130_fd_sc_hd__fill_2_682 VSS VDD VDD sky130_fd_sc_hd__fill_2
* cell instance sky130_fd_sc_hd__fill_2_683 r0 *1 0,0
Xsky130_fd_sc_hd__fill_2_683 VSS VDD VDD sky130_fd_sc_hd__fill_2
* cell instance sky130_fd_sc_hd__fill_2_684 r0 *1 0,0
Xsky130_fd_sc_hd__fill_2_684 VSS VDD VDD sky130_fd_sc_hd__fill_2
* cell instance sky130_fd_sc_hd__fill_2_685 r0 *1 0,0
Xsky130_fd_sc_hd__fill_2_685 VSS VDD VDD sky130_fd_sc_hd__fill_2
* cell instance sky130_fd_sc_hd__fill_2_686 r0 *1 0,0
Xsky130_fd_sc_hd__fill_2_686 VSS VDD VDD sky130_fd_sc_hd__fill_2
* cell instance sky130_fd_sc_hd__fill_2_687 r0 *1 0,0
Xsky130_fd_sc_hd__fill_2_687 VSS VDD VDD sky130_fd_sc_hd__fill_2
* cell instance sky130_fd_sc_hd__fill_2_688 r0 *1 0,0
Xsky130_fd_sc_hd__fill_2_688 VSS VDD VDD sky130_fd_sc_hd__fill_2
* cell instance sky130_fd_sc_hd__fill_2_689 r0 *1 0,0
Xsky130_fd_sc_hd__fill_2_689 VSS VDD VDD sky130_fd_sc_hd__fill_2
* cell instance sky130_fd_sc_hd__fill_2_690 r0 *1 0,0
Xsky130_fd_sc_hd__fill_2_690 VSS VDD VDD sky130_fd_sc_hd__fill_2
* cell instance sky130_fd_sc_hd__fill_2_691 r0 *1 0,0
Xsky130_fd_sc_hd__fill_2_691 VSS VDD VDD sky130_fd_sc_hd__fill_2
* cell instance sky130_fd_sc_hd__fill_2_692 r0 *1 0,0
Xsky130_fd_sc_hd__fill_2_692 VSS VDD VDD sky130_fd_sc_hd__fill_2
* cell instance sky130_fd_sc_hd__fill_2_693 r0 *1 0,0
Xsky130_fd_sc_hd__fill_2_693 VSS VDD VDD sky130_fd_sc_hd__fill_2
* cell instance sky130_fd_sc_hd__fill_2_694 r0 *1 0,0
Xsky130_fd_sc_hd__fill_2_694 VSS VDD VDD sky130_fd_sc_hd__fill_2
* cell instance sky130_fd_sc_hd__fill_2_695 r0 *1 0,0
Xsky130_fd_sc_hd__fill_2_695 VSS VDD VDD sky130_fd_sc_hd__fill_2
* cell instance sky130_fd_sc_hd__fill_2_696 r0 *1 0,0
Xsky130_fd_sc_hd__fill_2_696 VSS VDD VDD sky130_fd_sc_hd__fill_2
* cell instance sky130_fd_sc_hd__fill_2_697 r0 *1 0,0
Xsky130_fd_sc_hd__fill_2_697 VSS VDD VDD sky130_fd_sc_hd__fill_2
* cell instance sky130_fd_sc_hd__fill_2_698 r0 *1 0,0
Xsky130_fd_sc_hd__fill_2_698 VSS VDD VDD sky130_fd_sc_hd__fill_2
* cell instance sky130_fd_sc_hd__fill_2_699 r0 *1 0,0
Xsky130_fd_sc_hd__fill_2_699 VSS VDD VDD sky130_fd_sc_hd__fill_2
* cell instance sky130_fd_sc_hd__fill_2_700 r0 *1 0,0
Xsky130_fd_sc_hd__fill_2_700 VSS VDD VDD sky130_fd_sc_hd__fill_2
* cell instance sky130_fd_sc_hd__fill_2_701 r0 *1 0,0
Xsky130_fd_sc_hd__fill_2_701 VSS VDD VDD sky130_fd_sc_hd__fill_2
* cell instance sky130_fd_sc_hd__fill_2_702 r0 *1 0,0
Xsky130_fd_sc_hd__fill_2_702 VSS VDD VDD sky130_fd_sc_hd__fill_2
* cell instance sky130_fd_sc_hd__fill_2_703 r0 *1 0,0
Xsky130_fd_sc_hd__fill_2_703 VSS VDD VDD sky130_fd_sc_hd__fill_2
* cell instance sky130_fd_sc_hd__fill_2_704 r0 *1 0,0
Xsky130_fd_sc_hd__fill_2_704 VSS VDD VDD sky130_fd_sc_hd__fill_2
* cell instance sky130_fd_sc_hd__fill_2_705 r0 *1 0,0
Xsky130_fd_sc_hd__fill_2_705 VSS VDD VDD sky130_fd_sc_hd__fill_2
* cell instance sky130_fd_sc_hd__fill_2_706 r0 *1 0,0
Xsky130_fd_sc_hd__fill_2_706 VSS VDD VDD sky130_fd_sc_hd__fill_2
* cell instance sky130_fd_sc_hd__fill_2_707 r0 *1 0,0
Xsky130_fd_sc_hd__fill_2_707 VSS VDD VDD sky130_fd_sc_hd__fill_2
* cell instance sky130_fd_sc_hd__fill_2_708 r0 *1 0,0
Xsky130_fd_sc_hd__fill_2_708 VSS VDD VDD sky130_fd_sc_hd__fill_2
* cell instance sky130_fd_sc_hd__fill_2_709 r0 *1 0,0
Xsky130_fd_sc_hd__fill_2_709 VSS VDD VDD sky130_fd_sc_hd__fill_2
* cell instance sky130_fd_sc_hd__fill_2_710 r0 *1 0,0
Xsky130_fd_sc_hd__fill_2_710 VSS VDD VDD sky130_fd_sc_hd__fill_2
* cell instance sky130_fd_sc_hd__fill_2_711 r0 *1 0,0
Xsky130_fd_sc_hd__fill_2_711 VSS VDD VDD sky130_fd_sc_hd__fill_2
* cell instance sky130_fd_sc_hd__fill_2_712 r0 *1 0,0
Xsky130_fd_sc_hd__fill_2_712 VSS VDD VDD sky130_fd_sc_hd__fill_2
* cell instance sky130_fd_sc_hd__fill_2_713 r0 *1 0,0
Xsky130_fd_sc_hd__fill_2_713 VSS VDD VDD sky130_fd_sc_hd__fill_2
* cell instance sky130_fd_sc_hd__fill_2_714 r0 *1 0,0
Xsky130_fd_sc_hd__fill_2_714 VSS VDD VDD sky130_fd_sc_hd__fill_2
* cell instance sky130_fd_sc_hd__fill_2_715 r0 *1 0,0
Xsky130_fd_sc_hd__fill_2_715 VSS VDD VDD sky130_fd_sc_hd__fill_2
* cell instance sky130_fd_sc_hd__fill_2_716 r0 *1 0,0
Xsky130_fd_sc_hd__fill_2_716 VSS VDD VDD sky130_fd_sc_hd__fill_2
* cell instance sky130_fd_sc_hd__fill_2_717 r0 *1 0,0
Xsky130_fd_sc_hd__fill_2_717 VSS VDD VDD sky130_fd_sc_hd__fill_2
* cell instance sky130_fd_sc_hd__fill_2_718 r0 *1 0,0
Xsky130_fd_sc_hd__fill_2_718 VSS VDD VDD sky130_fd_sc_hd__fill_2
* cell instance sky130_fd_sc_hd__fill_2_719 r0 *1 0,0
Xsky130_fd_sc_hd__fill_2_719 VSS VDD VDD sky130_fd_sc_hd__fill_2
* cell instance sky130_fd_sc_hd__fill_2_720 r0 *1 0,0
Xsky130_fd_sc_hd__fill_2_720 VSS VDD VDD sky130_fd_sc_hd__fill_2
* cell instance sky130_fd_sc_hd__fill_2_721 r0 *1 0,0
Xsky130_fd_sc_hd__fill_2_721 VSS VDD VDD sky130_fd_sc_hd__fill_2
* cell instance sky130_fd_sc_hd__fill_4_0 r0 *1 0,0
Xsky130_fd_sc_hd__fill_4_0 VSS VDD VDD sky130_fd_sc_hd__fill_4
* cell instance sky130_fd_sc_hd__fill_4_1 r0 *1 0,0
Xsky130_fd_sc_hd__fill_4_1 VSS VDD VDD sky130_fd_sc_hd__fill_4
* cell instance sky130_fd_sc_hd__fill_4_2 r0 *1 0,0
Xsky130_fd_sc_hd__fill_4_2 VSS VDD VDD sky130_fd_sc_hd__fill_4
* cell instance sky130_fd_sc_hd__fill_4_3 r0 *1 0,0
Xsky130_fd_sc_hd__fill_4_3 VSS VDD VDD sky130_fd_sc_hd__fill_4
* cell instance sky130_fd_sc_hd__fill_4_4 r0 *1 0,0
Xsky130_fd_sc_hd__fill_4_4 VSS VDD VDD sky130_fd_sc_hd__fill_4
* cell instance sky130_fd_sc_hd__fill_4_5 r0 *1 0,0
Xsky130_fd_sc_hd__fill_4_5 VSS VDD VDD sky130_fd_sc_hd__fill_4
* cell instance sky130_fd_sc_hd__fill_4_6 r0 *1 0,0
Xsky130_fd_sc_hd__fill_4_6 VSS VDD VDD sky130_fd_sc_hd__fill_4
* cell instance sky130_fd_sc_hd__fill_4_7 r0 *1 0,0
Xsky130_fd_sc_hd__fill_4_7 VSS VDD VDD sky130_fd_sc_hd__fill_4
* cell instance sky130_fd_sc_hd__fill_4_8 r0 *1 0,0
Xsky130_fd_sc_hd__fill_4_8 VSS VDD VDD sky130_fd_sc_hd__fill_4
* cell instance sky130_fd_sc_hd__fill_4_9 r0 *1 0,0
Xsky130_fd_sc_hd__fill_4_9 VSS VDD VDD sky130_fd_sc_hd__fill_4
* cell instance sky130_fd_sc_hd__fill_4_10 r0 *1 0,0
Xsky130_fd_sc_hd__fill_4_10 VSS VDD VDD sky130_fd_sc_hd__fill_4
* cell instance sky130_fd_sc_hd__fill_4_11 r0 *1 0,0
Xsky130_fd_sc_hd__fill_4_11 VSS VDD VDD sky130_fd_sc_hd__fill_4
* cell instance sky130_fd_sc_hd__fill_4_12 r0 *1 0,0
Xsky130_fd_sc_hd__fill_4_12 VSS VDD VDD sky130_fd_sc_hd__fill_4
* cell instance sky130_fd_sc_hd__fill_4_13 r0 *1 0,0
Xsky130_fd_sc_hd__fill_4_13 VSS VDD VDD sky130_fd_sc_hd__fill_4
* cell instance sky130_fd_sc_hd__fill_4_14 r0 *1 0,0
Xsky130_fd_sc_hd__fill_4_14 VSS VDD VDD sky130_fd_sc_hd__fill_4
* cell instance sky130_fd_sc_hd__fill_4_15 r0 *1 0,0
Xsky130_fd_sc_hd__fill_4_15 VSS VDD VDD sky130_fd_sc_hd__fill_4
* cell instance sky130_fd_sc_hd__fill_4_16 r0 *1 0,0
Xsky130_fd_sc_hd__fill_4_16 VSS VDD VDD sky130_fd_sc_hd__fill_4
* cell instance sky130_fd_sc_hd__fill_4_17 r0 *1 0,0
Xsky130_fd_sc_hd__fill_4_17 VSS VDD VDD sky130_fd_sc_hd__fill_4
* cell instance sky130_fd_sc_hd__fill_4_18 r0 *1 0,0
Xsky130_fd_sc_hd__fill_4_18 VSS VDD VDD sky130_fd_sc_hd__fill_4
* cell instance sky130_fd_sc_hd__fill_4_19 r0 *1 0,0
Xsky130_fd_sc_hd__fill_4_19 VSS VDD VDD sky130_fd_sc_hd__fill_4
* cell instance sky130_fd_sc_hd__fill_4_20 r0 *1 0,0
Xsky130_fd_sc_hd__fill_4_20 VSS VDD VDD sky130_fd_sc_hd__fill_4
* cell instance sky130_fd_sc_hd__fill_4_21 r0 *1 0,0
Xsky130_fd_sc_hd__fill_4_21 VSS VDD VDD sky130_fd_sc_hd__fill_4
* cell instance sky130_fd_sc_hd__fill_4_22 r0 *1 0,0
Xsky130_fd_sc_hd__fill_4_22 VSS VDD VDD sky130_fd_sc_hd__fill_4
* cell instance sky130_fd_sc_hd__fill_4_23 r0 *1 0,0
Xsky130_fd_sc_hd__fill_4_23 VSS VDD VDD sky130_fd_sc_hd__fill_4
* cell instance sky130_fd_sc_hd__fill_4_24 r0 *1 0,0
Xsky130_fd_sc_hd__fill_4_24 VSS VDD VDD sky130_fd_sc_hd__fill_4
* cell instance sky130_fd_sc_hd__fill_4_25 r0 *1 0,0
Xsky130_fd_sc_hd__fill_4_25 VSS VDD VDD sky130_fd_sc_hd__fill_4
* cell instance sky130_fd_sc_hd__fill_4_26 r0 *1 0,0
Xsky130_fd_sc_hd__fill_4_26 VSS VDD VDD sky130_fd_sc_hd__fill_4
* cell instance sky130_fd_sc_hd__fill_4_27 r0 *1 0,0
Xsky130_fd_sc_hd__fill_4_27 VSS VDD VDD sky130_fd_sc_hd__fill_4
* cell instance sky130_fd_sc_hd__fill_4_28 r0 *1 0,0
Xsky130_fd_sc_hd__fill_4_28 VSS VDD VDD sky130_fd_sc_hd__fill_4
* cell instance sky130_fd_sc_hd__fill_4_29 r0 *1 0,0
Xsky130_fd_sc_hd__fill_4_29 VSS VDD VDD sky130_fd_sc_hd__fill_4
* cell instance sky130_fd_sc_hd__fill_4_30 r0 *1 0,0
Xsky130_fd_sc_hd__fill_4_30 VSS VDD VDD sky130_fd_sc_hd__fill_4
* cell instance sky130_fd_sc_hd__fill_4_31 r0 *1 0,0
Xsky130_fd_sc_hd__fill_4_31 VSS VDD VDD sky130_fd_sc_hd__fill_4
* cell instance sky130_fd_sc_hd__fill_4_32 r0 *1 0,0
Xsky130_fd_sc_hd__fill_4_32 VSS VDD VDD sky130_fd_sc_hd__fill_4
* cell instance sky130_fd_sc_hd__fill_4_33 r0 *1 0,0
Xsky130_fd_sc_hd__fill_4_33 VSS VDD VDD sky130_fd_sc_hd__fill_4
* cell instance sky130_fd_sc_hd__fill_4_34 r0 *1 0,0
Xsky130_fd_sc_hd__fill_4_34 VSS VDD VDD sky130_fd_sc_hd__fill_4
* cell instance sky130_fd_sc_hd__fill_4_35 r0 *1 0,0
Xsky130_fd_sc_hd__fill_4_35 VSS VDD VDD sky130_fd_sc_hd__fill_4
* cell instance sky130_fd_sc_hd__fill_4_36 r0 *1 0,0
Xsky130_fd_sc_hd__fill_4_36 VSS VDD VDD sky130_fd_sc_hd__fill_4
* cell instance sky130_fd_sc_hd__fill_4_37 r0 *1 0,0
Xsky130_fd_sc_hd__fill_4_37 VSS VDD VDD sky130_fd_sc_hd__fill_4
* cell instance sky130_fd_sc_hd__fill_4_38 r0 *1 0,0
Xsky130_fd_sc_hd__fill_4_38 VSS VDD VDD sky130_fd_sc_hd__fill_4
* cell instance sky130_fd_sc_hd__fill_4_39 r0 *1 0,0
Xsky130_fd_sc_hd__fill_4_39 VSS VDD VDD sky130_fd_sc_hd__fill_4
* cell instance sky130_fd_sc_hd__fill_4_40 r0 *1 0,0
Xsky130_fd_sc_hd__fill_4_40 VSS VDD VDD sky130_fd_sc_hd__fill_4
* cell instance sky130_fd_sc_hd__fill_4_41 r0 *1 0,0
Xsky130_fd_sc_hd__fill_4_41 VSS VDD VDD sky130_fd_sc_hd__fill_4
* cell instance sky130_fd_sc_hd__fill_4_42 r0 *1 0,0
Xsky130_fd_sc_hd__fill_4_42 VSS VDD VDD sky130_fd_sc_hd__fill_4
* cell instance sky130_fd_sc_hd__fill_4_43 r0 *1 0,0
Xsky130_fd_sc_hd__fill_4_43 VSS VDD VDD sky130_fd_sc_hd__fill_4
* cell instance sky130_fd_sc_hd__fill_4_44 r0 *1 0,0
Xsky130_fd_sc_hd__fill_4_44 VSS VDD VDD sky130_fd_sc_hd__fill_4
* cell instance sky130_fd_sc_hd__fill_4_45 r0 *1 0,0
Xsky130_fd_sc_hd__fill_4_45 VSS VDD VDD sky130_fd_sc_hd__fill_4
* cell instance sky130_fd_sc_hd__fill_4_46 r0 *1 0,0
Xsky130_fd_sc_hd__fill_4_46 VSS VDD VDD sky130_fd_sc_hd__fill_4
* cell instance sky130_fd_sc_hd__fill_4_47 r0 *1 0,0
Xsky130_fd_sc_hd__fill_4_47 VSS VDD VDD sky130_fd_sc_hd__fill_4
* cell instance sky130_fd_sc_hd__fill_4_48 r0 *1 0,0
Xsky130_fd_sc_hd__fill_4_48 VSS VDD VDD sky130_fd_sc_hd__fill_4
* cell instance sky130_fd_sc_hd__fill_4_49 r0 *1 0,0
Xsky130_fd_sc_hd__fill_4_49 VSS VDD VDD sky130_fd_sc_hd__fill_4
* cell instance sky130_fd_sc_hd__fill_4_50 r0 *1 0,0
Xsky130_fd_sc_hd__fill_4_50 VSS VDD VDD sky130_fd_sc_hd__fill_4
* cell instance sky130_fd_sc_hd__fill_4_51 r0 *1 0,0
Xsky130_fd_sc_hd__fill_4_51 VSS VDD VDD sky130_fd_sc_hd__fill_4
* cell instance sky130_fd_sc_hd__fill_4_52 r0 *1 0,0
Xsky130_fd_sc_hd__fill_4_52 VSS VDD VDD sky130_fd_sc_hd__fill_4
* cell instance sky130_fd_sc_hd__fill_4_53 r0 *1 0,0
Xsky130_fd_sc_hd__fill_4_53 VSS VDD VDD sky130_fd_sc_hd__fill_4
* cell instance sky130_fd_sc_hd__fill_4_54 r0 *1 0,0
Xsky130_fd_sc_hd__fill_4_54 VSS VDD VDD sky130_fd_sc_hd__fill_4
* cell instance sky130_fd_sc_hd__fill_4_55 r0 *1 0,0
Xsky130_fd_sc_hd__fill_4_55 VSS VDD VDD sky130_fd_sc_hd__fill_4
* cell instance sky130_fd_sc_hd__fill_4_56 r0 *1 0,0
Xsky130_fd_sc_hd__fill_4_56 VSS VDD VDD sky130_fd_sc_hd__fill_4
* cell instance sky130_fd_sc_hd__fill_4_57 r0 *1 0,0
Xsky130_fd_sc_hd__fill_4_57 VSS VDD VDD sky130_fd_sc_hd__fill_4
* cell instance sky130_fd_sc_hd__fill_4_58 r0 *1 0,0
Xsky130_fd_sc_hd__fill_4_58 VSS VDD VDD sky130_fd_sc_hd__fill_4
* cell instance sky130_fd_sc_hd__fill_4_59 r0 *1 0,0
Xsky130_fd_sc_hd__fill_4_59 VSS VDD VDD sky130_fd_sc_hd__fill_4
* cell instance sky130_fd_sc_hd__fill_4_60 r0 *1 0,0
Xsky130_fd_sc_hd__fill_4_60 VSS VDD VDD sky130_fd_sc_hd__fill_4
* cell instance sky130_fd_sc_hd__fill_4_61 r0 *1 0,0
Xsky130_fd_sc_hd__fill_4_61 VSS VDD VDD sky130_fd_sc_hd__fill_4
* cell instance sky130_fd_sc_hd__fill_4_62 r0 *1 0,0
Xsky130_fd_sc_hd__fill_4_62 VSS VDD VDD sky130_fd_sc_hd__fill_4
* cell instance sky130_fd_sc_hd__fill_4_63 r0 *1 0,0
Xsky130_fd_sc_hd__fill_4_63 VSS VDD VDD sky130_fd_sc_hd__fill_4
* cell instance sky130_fd_sc_hd__fill_4_64 r0 *1 0,0
Xsky130_fd_sc_hd__fill_4_64 VSS VDD VDD sky130_fd_sc_hd__fill_4
* cell instance sky130_fd_sc_hd__fill_4_65 r0 *1 0,0
Xsky130_fd_sc_hd__fill_4_65 VSS VDD VDD sky130_fd_sc_hd__fill_4
* cell instance sky130_fd_sc_hd__fill_4_66 r0 *1 0,0
Xsky130_fd_sc_hd__fill_4_66 VSS VDD VDD sky130_fd_sc_hd__fill_4
* cell instance sky130_fd_sc_hd__fill_4_67 r0 *1 0,0
Xsky130_fd_sc_hd__fill_4_67 VSS VDD VDD sky130_fd_sc_hd__fill_4
* cell instance sky130_fd_sc_hd__fill_4_68 r0 *1 0,0
Xsky130_fd_sc_hd__fill_4_68 VSS VDD VDD sky130_fd_sc_hd__fill_4
* cell instance sky130_fd_sc_hd__fill_4_69 r0 *1 0,0
Xsky130_fd_sc_hd__fill_4_69 VSS VDD VDD sky130_fd_sc_hd__fill_4
* cell instance sky130_fd_sc_hd__fill_4_70 r0 *1 0,0
Xsky130_fd_sc_hd__fill_4_70 VSS VDD VDD sky130_fd_sc_hd__fill_4
* cell instance sky130_fd_sc_hd__fill_4_71 r0 *1 0,0
Xsky130_fd_sc_hd__fill_4_71 VSS VDD VDD sky130_fd_sc_hd__fill_4
* cell instance sky130_fd_sc_hd__fill_4_72 r0 *1 0,0
Xsky130_fd_sc_hd__fill_4_72 VSS VDD VDD sky130_fd_sc_hd__fill_4
* cell instance sky130_fd_sc_hd__fill_4_73 r0 *1 0,0
Xsky130_fd_sc_hd__fill_4_73 VSS VDD VDD sky130_fd_sc_hd__fill_4
* cell instance sky130_fd_sc_hd__fill_4_74 r0 *1 0,0
Xsky130_fd_sc_hd__fill_4_74 VSS VDD VDD sky130_fd_sc_hd__fill_4
* cell instance sky130_fd_sc_hd__fill_4_75 r0 *1 0,0
Xsky130_fd_sc_hd__fill_4_75 VSS VDD VDD sky130_fd_sc_hd__fill_4
* cell instance sky130_fd_sc_hd__fill_4_76 r0 *1 0,0
Xsky130_fd_sc_hd__fill_4_76 VSS VDD VDD sky130_fd_sc_hd__fill_4
* cell instance sky130_fd_sc_hd__fill_4_77 r0 *1 0,0
Xsky130_fd_sc_hd__fill_4_77 VSS VDD VDD sky130_fd_sc_hd__fill_4
* cell instance sky130_fd_sc_hd__fill_4_78 r0 *1 0,0
Xsky130_fd_sc_hd__fill_4_78 VSS VDD VDD sky130_fd_sc_hd__fill_4
* cell instance sky130_fd_sc_hd__fill_4_79 r0 *1 0,0
Xsky130_fd_sc_hd__fill_4_79 VSS VDD VDD sky130_fd_sc_hd__fill_4
* cell instance sky130_fd_sc_hd__fill_4_80 r0 *1 0,0
Xsky130_fd_sc_hd__fill_4_80 VSS VDD VDD sky130_fd_sc_hd__fill_4
* cell instance sky130_fd_sc_hd__fill_4_81 r0 *1 0,0
Xsky130_fd_sc_hd__fill_4_81 VSS VDD VDD sky130_fd_sc_hd__fill_4
* cell instance sky130_fd_sc_hd__fill_4_82 r0 *1 0,0
Xsky130_fd_sc_hd__fill_4_82 VSS VDD VDD sky130_fd_sc_hd__fill_4
* cell instance sky130_fd_sc_hd__fill_4_83 r0 *1 0,0
Xsky130_fd_sc_hd__fill_4_83 VSS VDD VDD sky130_fd_sc_hd__fill_4
* cell instance sky130_fd_sc_hd__fill_4_84 r0 *1 0,0
Xsky130_fd_sc_hd__fill_4_84 VSS VDD VDD sky130_fd_sc_hd__fill_4
* cell instance sky130_fd_sc_hd__fill_4_85 r0 *1 0,0
Xsky130_fd_sc_hd__fill_4_85 VSS VDD VDD sky130_fd_sc_hd__fill_4
* cell instance sky130_fd_sc_hd__fill_4_86 r0 *1 0,0
Xsky130_fd_sc_hd__fill_4_86 VSS VDD VDD sky130_fd_sc_hd__fill_4
* cell instance sky130_fd_sc_hd__fill_4_87 r0 *1 0,0
Xsky130_fd_sc_hd__fill_4_87 VSS VDD VDD sky130_fd_sc_hd__fill_4
* cell instance sky130_fd_sc_hd__fill_4_88 r0 *1 0,0
Xsky130_fd_sc_hd__fill_4_88 VSS VDD VDD sky130_fd_sc_hd__fill_4
* cell instance sky130_fd_sc_hd__fill_4_89 r0 *1 0,0
Xsky130_fd_sc_hd__fill_4_89 VSS VDD VDD sky130_fd_sc_hd__fill_4
* cell instance sky130_fd_sc_hd__fill_4_90 r0 *1 0,0
Xsky130_fd_sc_hd__fill_4_90 VSS VDD VDD sky130_fd_sc_hd__fill_4
* cell instance sky130_fd_sc_hd__fill_4_91 r0 *1 0,0
Xsky130_fd_sc_hd__fill_4_91 VSS VDD VDD sky130_fd_sc_hd__fill_4
* cell instance sky130_fd_sc_hd__fill_4_92 r0 *1 0,0
Xsky130_fd_sc_hd__fill_4_92 VSS VDD VDD sky130_fd_sc_hd__fill_4
* cell instance sky130_fd_sc_hd__fill_4_93 r0 *1 0,0
Xsky130_fd_sc_hd__fill_4_93 VSS VDD VDD sky130_fd_sc_hd__fill_4
* cell instance sky130_fd_sc_hd__fill_4_94 r0 *1 0,0
Xsky130_fd_sc_hd__fill_4_94 VSS VDD VDD sky130_fd_sc_hd__fill_4
* cell instance sky130_fd_sc_hd__fill_4_95 r0 *1 0,0
Xsky130_fd_sc_hd__fill_4_95 VSS VDD VDD sky130_fd_sc_hd__fill_4
* cell instance sky130_fd_sc_hd__fill_4_96 r0 *1 0,0
Xsky130_fd_sc_hd__fill_4_96 VSS VDD VDD sky130_fd_sc_hd__fill_4
* cell instance sky130_fd_sc_hd__fill_4_97 r0 *1 0,0
Xsky130_fd_sc_hd__fill_4_97 VSS VDD VDD sky130_fd_sc_hd__fill_4
* cell instance sky130_fd_sc_hd__fill_4_98 r0 *1 0,0
Xsky130_fd_sc_hd__fill_4_98 VSS VDD VDD sky130_fd_sc_hd__fill_4
* cell instance sky130_fd_sc_hd__fill_4_99 r0 *1 0,0
Xsky130_fd_sc_hd__fill_4_99 VSS VDD VDD sky130_fd_sc_hd__fill_4
* cell instance sky130_fd_sc_hd__fill_4_100 r0 *1 0,0
Xsky130_fd_sc_hd__fill_4_100 VSS VDD VDD sky130_fd_sc_hd__fill_4
* cell instance sky130_fd_sc_hd__fill_4_101 r0 *1 0,0
Xsky130_fd_sc_hd__fill_4_101 VSS VDD VDD sky130_fd_sc_hd__fill_4
* cell instance sky130_fd_sc_hd__fill_4_102 r0 *1 0,0
Xsky130_fd_sc_hd__fill_4_102 VSS VDD VDD sky130_fd_sc_hd__fill_4
* cell instance sky130_fd_sc_hd__fill_4_103 r0 *1 0,0
Xsky130_fd_sc_hd__fill_4_103 VSS VDD VDD sky130_fd_sc_hd__fill_4
* cell instance sky130_fd_sc_hd__fill_4_104 r0 *1 0,0
Xsky130_fd_sc_hd__fill_4_104 VSS VDD VDD sky130_fd_sc_hd__fill_4
* cell instance sky130_fd_sc_hd__fill_4_105 r0 *1 0,0
Xsky130_fd_sc_hd__fill_4_105 VSS VDD VDD sky130_fd_sc_hd__fill_4
* cell instance sky130_fd_sc_hd__fill_4_106 r0 *1 0,0
Xsky130_fd_sc_hd__fill_4_106 VSS VDD VDD sky130_fd_sc_hd__fill_4
* cell instance sky130_fd_sc_hd__fill_4_107 r0 *1 0,0
Xsky130_fd_sc_hd__fill_4_107 VSS VDD VDD sky130_fd_sc_hd__fill_4
* cell instance sky130_fd_sc_hd__fill_4_108 r0 *1 0,0
Xsky130_fd_sc_hd__fill_4_108 VSS VDD VDD sky130_fd_sc_hd__fill_4
* cell instance sky130_fd_sc_hd__fill_4_109 r0 *1 0,0
Xsky130_fd_sc_hd__fill_4_109 VSS VDD VDD sky130_fd_sc_hd__fill_4
* cell instance sky130_fd_sc_hd__fill_4_110 r0 *1 0,0
Xsky130_fd_sc_hd__fill_4_110 VSS VDD VDD sky130_fd_sc_hd__fill_4
* cell instance sky130_fd_sc_hd__fill_4_111 r0 *1 0,0
Xsky130_fd_sc_hd__fill_4_111 VSS VDD VDD sky130_fd_sc_hd__fill_4
* cell instance sky130_fd_sc_hd__fill_4_112 r0 *1 0,0
Xsky130_fd_sc_hd__fill_4_112 VSS VDD VDD sky130_fd_sc_hd__fill_4
* cell instance sky130_fd_sc_hd__fill_4_113 r0 *1 0,0
Xsky130_fd_sc_hd__fill_4_113 VSS VDD VDD sky130_fd_sc_hd__fill_4
* cell instance sky130_fd_sc_hd__fill_4_114 r0 *1 0,0
Xsky130_fd_sc_hd__fill_4_114 VSS VDD VDD sky130_fd_sc_hd__fill_4
* cell instance sky130_fd_sc_hd__fill_4_115 r0 *1 0,0
Xsky130_fd_sc_hd__fill_4_115 VSS VDD VDD sky130_fd_sc_hd__fill_4
* cell instance sky130_fd_sc_hd__fill_4_116 r0 *1 0,0
Xsky130_fd_sc_hd__fill_4_116 VSS VDD VDD sky130_fd_sc_hd__fill_4
* cell instance sky130_fd_sc_hd__fill_4_117 r0 *1 0,0
Xsky130_fd_sc_hd__fill_4_117 VSS VDD VDD sky130_fd_sc_hd__fill_4
* cell instance sky130_fd_sc_hd__fill_4_118 r0 *1 0,0
Xsky130_fd_sc_hd__fill_4_118 VSS VDD VDD sky130_fd_sc_hd__fill_4
* cell instance sky130_fd_sc_hd__fill_4_119 r0 *1 0,0
Xsky130_fd_sc_hd__fill_4_119 VSS VDD VDD sky130_fd_sc_hd__fill_4
* cell instance sky130_fd_sc_hd__fill_4_120 r0 *1 0,0
Xsky130_fd_sc_hd__fill_4_120 VSS VDD VDD sky130_fd_sc_hd__fill_4
* cell instance sky130_fd_sc_hd__fill_4_121 r0 *1 0,0
Xsky130_fd_sc_hd__fill_4_121 VSS VDD VDD sky130_fd_sc_hd__fill_4
* cell instance sky130_fd_sc_hd__fill_4_122 r0 *1 0,0
Xsky130_fd_sc_hd__fill_4_122 VSS VDD VDD sky130_fd_sc_hd__fill_4
* cell instance sky130_fd_sc_hd__fill_4_123 r0 *1 0,0
Xsky130_fd_sc_hd__fill_4_123 VSS VDD VDD sky130_fd_sc_hd__fill_4
* cell instance sky130_fd_sc_hd__fill_4_124 r0 *1 0,0
Xsky130_fd_sc_hd__fill_4_124 VSS VDD VDD sky130_fd_sc_hd__fill_4
* cell instance sky130_fd_sc_hd__fill_4_125 r0 *1 0,0
Xsky130_fd_sc_hd__fill_4_125 VSS VDD VDD sky130_fd_sc_hd__fill_4
* cell instance sky130_fd_sc_hd__fill_4_126 r0 *1 0,0
Xsky130_fd_sc_hd__fill_4_126 VSS VDD VDD sky130_fd_sc_hd__fill_4
* cell instance sky130_fd_sc_hd__fill_4_127 r0 *1 0,0
Xsky130_fd_sc_hd__fill_4_127 VSS VDD VDD sky130_fd_sc_hd__fill_4
* cell instance sky130_fd_sc_hd__fill_4_128 r0 *1 0,0
Xsky130_fd_sc_hd__fill_4_128 VSS VDD VDD sky130_fd_sc_hd__fill_4
* cell instance sky130_fd_sc_hd__fill_4_129 r0 *1 0,0
Xsky130_fd_sc_hd__fill_4_129 VSS VDD VDD sky130_fd_sc_hd__fill_4
* cell instance sky130_fd_sc_hd__fill_4_130 r0 *1 0,0
Xsky130_fd_sc_hd__fill_4_130 VSS VDD VDD sky130_fd_sc_hd__fill_4
* cell instance sky130_fd_sc_hd__fill_4_131 r0 *1 0,0
Xsky130_fd_sc_hd__fill_4_131 VSS VDD VDD sky130_fd_sc_hd__fill_4
* cell instance sky130_fd_sc_hd__fill_4_132 r0 *1 0,0
Xsky130_fd_sc_hd__fill_4_132 VSS VDD VDD sky130_fd_sc_hd__fill_4
* cell instance sky130_fd_sc_hd__fill_4_133 r0 *1 0,0
Xsky130_fd_sc_hd__fill_4_133 VSS VDD VDD sky130_fd_sc_hd__fill_4
* cell instance sky130_fd_sc_hd__fill_4_134 r0 *1 0,0
Xsky130_fd_sc_hd__fill_4_134 VSS VDD VDD sky130_fd_sc_hd__fill_4
* cell instance sky130_fd_sc_hd__fill_4_135 r0 *1 0,0
Xsky130_fd_sc_hd__fill_4_135 VSS VDD VDD sky130_fd_sc_hd__fill_4
* cell instance sky130_fd_sc_hd__fill_4_136 r0 *1 0,0
Xsky130_fd_sc_hd__fill_4_136 VSS VDD VDD sky130_fd_sc_hd__fill_4
* cell instance sky130_fd_sc_hd__fill_4_137 r0 *1 0,0
Xsky130_fd_sc_hd__fill_4_137 VSS VDD VDD sky130_fd_sc_hd__fill_4
* cell instance sky130_fd_sc_hd__fill_4_138 r0 *1 0,0
Xsky130_fd_sc_hd__fill_4_138 VSS VDD VDD sky130_fd_sc_hd__fill_4
* cell instance sky130_fd_sc_hd__fill_4_139 r0 *1 0,0
Xsky130_fd_sc_hd__fill_4_139 VSS VDD VDD sky130_fd_sc_hd__fill_4
* cell instance sky130_fd_sc_hd__fill_4_140 r0 *1 0,0
Xsky130_fd_sc_hd__fill_4_140 VSS VDD VDD sky130_fd_sc_hd__fill_4
* cell instance sky130_fd_sc_hd__fill_4_141 r0 *1 0,0
Xsky130_fd_sc_hd__fill_4_141 VSS VDD VDD sky130_fd_sc_hd__fill_4
* cell instance sky130_fd_sc_hd__fill_4_142 r0 *1 0,0
Xsky130_fd_sc_hd__fill_4_142 VSS VDD VDD sky130_fd_sc_hd__fill_4
* cell instance sky130_fd_sc_hd__fill_4_143 r0 *1 0,0
Xsky130_fd_sc_hd__fill_4_143 VSS VDD VDD sky130_fd_sc_hd__fill_4
* cell instance sky130_fd_sc_hd__fill_4_144 r0 *1 0,0
Xsky130_fd_sc_hd__fill_4_144 VSS VDD VDD sky130_fd_sc_hd__fill_4
* cell instance sky130_fd_sc_hd__fill_4_145 r0 *1 0,0
Xsky130_fd_sc_hd__fill_4_145 VSS VDD VDD sky130_fd_sc_hd__fill_4
* cell instance sky130_fd_sc_hd__fill_4_146 r0 *1 0,0
Xsky130_fd_sc_hd__fill_4_146 VSS VDD VDD sky130_fd_sc_hd__fill_4
* cell instance sky130_fd_sc_hd__fill_4_147 r0 *1 0,0
Xsky130_fd_sc_hd__fill_4_147 VSS VDD VDD sky130_fd_sc_hd__fill_4
* cell instance sky130_fd_sc_hd__fill_4_148 r0 *1 0,0
Xsky130_fd_sc_hd__fill_4_148 VSS VDD VDD sky130_fd_sc_hd__fill_4
* cell instance sky130_fd_sc_hd__fill_4_149 r0 *1 0,0
Xsky130_fd_sc_hd__fill_4_149 VSS VDD VDD sky130_fd_sc_hd__fill_4
* cell instance sky130_fd_sc_hd__fill_4_150 r0 *1 0,0
Xsky130_fd_sc_hd__fill_4_150 VSS VDD VDD sky130_fd_sc_hd__fill_4
* cell instance sky130_fd_sc_hd__fill_4_151 r0 *1 0,0
Xsky130_fd_sc_hd__fill_4_151 VSS VDD VDD sky130_fd_sc_hd__fill_4
* cell instance sky130_fd_sc_hd__fill_4_152 r0 *1 0,0
Xsky130_fd_sc_hd__fill_4_152 VSS VDD VDD sky130_fd_sc_hd__fill_4
* cell instance sky130_fd_sc_hd__fill_4_153 r0 *1 0,0
Xsky130_fd_sc_hd__fill_4_153 VSS VDD VDD sky130_fd_sc_hd__fill_4
* cell instance sky130_fd_sc_hd__fill_4_154 r0 *1 0,0
Xsky130_fd_sc_hd__fill_4_154 VSS VDD VDD sky130_fd_sc_hd__fill_4
* cell instance sky130_fd_sc_hd__fill_4_155 r0 *1 0,0
Xsky130_fd_sc_hd__fill_4_155 VSS VDD VDD sky130_fd_sc_hd__fill_4
* cell instance sky130_fd_sc_hd__fill_4_156 r0 *1 0,0
Xsky130_fd_sc_hd__fill_4_156 VSS VDD VDD sky130_fd_sc_hd__fill_4
* cell instance sky130_fd_sc_hd__fill_4_157 r0 *1 0,0
Xsky130_fd_sc_hd__fill_4_157 VSS VDD VDD sky130_fd_sc_hd__fill_4
* cell instance sky130_fd_sc_hd__fill_4_158 r0 *1 0,0
Xsky130_fd_sc_hd__fill_4_158 VSS VDD VDD sky130_fd_sc_hd__fill_4
* cell instance sky130_fd_sc_hd__fill_4_159 r0 *1 0,0
Xsky130_fd_sc_hd__fill_4_159 VSS VDD VDD sky130_fd_sc_hd__fill_4
* cell instance sky130_fd_sc_hd__fill_4_160 r0 *1 0,0
Xsky130_fd_sc_hd__fill_4_160 VSS VDD VDD sky130_fd_sc_hd__fill_4
* cell instance sky130_fd_sc_hd__fill_4_161 r0 *1 0,0
Xsky130_fd_sc_hd__fill_4_161 VSS VDD VDD sky130_fd_sc_hd__fill_4
* cell instance sky130_fd_sc_hd__fill_4_162 r0 *1 0,0
Xsky130_fd_sc_hd__fill_4_162 VSS VDD VDD sky130_fd_sc_hd__fill_4
* cell instance sky130_fd_sc_hd__fill_4_163 r0 *1 0,0
Xsky130_fd_sc_hd__fill_4_163 VSS VDD VDD sky130_fd_sc_hd__fill_4
* cell instance sky130_fd_sc_hd__fill_4_164 r0 *1 0,0
Xsky130_fd_sc_hd__fill_4_164 VSS VDD VDD sky130_fd_sc_hd__fill_4
* cell instance sky130_fd_sc_hd__fill_4_165 r0 *1 0,0
Xsky130_fd_sc_hd__fill_4_165 VSS VDD VDD sky130_fd_sc_hd__fill_4
* cell instance sky130_fd_sc_hd__fill_4_166 r0 *1 0,0
Xsky130_fd_sc_hd__fill_4_166 VSS VDD VDD sky130_fd_sc_hd__fill_4
* cell instance sky130_fd_sc_hd__fill_4_167 r0 *1 0,0
Xsky130_fd_sc_hd__fill_4_167 VSS VDD VDD sky130_fd_sc_hd__fill_4
* cell instance sky130_fd_sc_hd__fill_4_168 r0 *1 0,0
Xsky130_fd_sc_hd__fill_4_168 VSS VDD VDD sky130_fd_sc_hd__fill_4
* cell instance sky130_fd_sc_hd__fill_4_169 r0 *1 0,0
Xsky130_fd_sc_hd__fill_4_169 VSS VDD VDD sky130_fd_sc_hd__fill_4
* cell instance sky130_fd_sc_hd__fill_4_170 r0 *1 0,0
Xsky130_fd_sc_hd__fill_4_170 VSS VDD VDD sky130_fd_sc_hd__fill_4
* cell instance sky130_fd_sc_hd__fill_4_171 r0 *1 0,0
Xsky130_fd_sc_hd__fill_4_171 VSS VDD VDD sky130_fd_sc_hd__fill_4
* cell instance sky130_fd_sc_hd__fill_4_172 r0 *1 0,0
Xsky130_fd_sc_hd__fill_4_172 VSS VDD VDD sky130_fd_sc_hd__fill_4
* cell instance sky130_fd_sc_hd__fill_4_173 r0 *1 0,0
Xsky130_fd_sc_hd__fill_4_173 VSS VDD VDD sky130_fd_sc_hd__fill_4
* cell instance sky130_fd_sc_hd__fill_4_174 r0 *1 0,0
Xsky130_fd_sc_hd__fill_4_174 VSS VDD VDD sky130_fd_sc_hd__fill_4
* cell instance sky130_fd_sc_hd__fill_4_175 r0 *1 0,0
Xsky130_fd_sc_hd__fill_4_175 VSS VDD VDD sky130_fd_sc_hd__fill_4
* cell instance sky130_fd_sc_hd__fill_4_176 r0 *1 0,0
Xsky130_fd_sc_hd__fill_4_176 VSS VDD VDD sky130_fd_sc_hd__fill_4
* cell instance sky130_fd_sc_hd__fill_4_177 r0 *1 0,0
Xsky130_fd_sc_hd__fill_4_177 VSS VDD VDD sky130_fd_sc_hd__fill_4
* cell instance sky130_fd_sc_hd__fill_4_178 r0 *1 0,0
Xsky130_fd_sc_hd__fill_4_178 VSS VDD VDD sky130_fd_sc_hd__fill_4
* cell instance sky130_fd_sc_hd__fill_4_179 r0 *1 0,0
Xsky130_fd_sc_hd__fill_4_179 VSS VDD VDD sky130_fd_sc_hd__fill_4
* cell instance sky130_fd_sc_hd__fill_4_180 r0 *1 0,0
Xsky130_fd_sc_hd__fill_4_180 VSS VDD VDD sky130_fd_sc_hd__fill_4
* cell instance sky130_fd_sc_hd__fill_4_181 r0 *1 0,0
Xsky130_fd_sc_hd__fill_4_181 VSS VDD VDD sky130_fd_sc_hd__fill_4
* cell instance sky130_fd_sc_hd__fill_4_182 r0 *1 0,0
Xsky130_fd_sc_hd__fill_4_182 VSS VDD VDD sky130_fd_sc_hd__fill_4
* cell instance sky130_fd_sc_hd__fill_4_183 r0 *1 0,0
Xsky130_fd_sc_hd__fill_4_183 VSS VDD VDD sky130_fd_sc_hd__fill_4
* cell instance sky130_fd_sc_hd__fill_4_184 r0 *1 0,0
Xsky130_fd_sc_hd__fill_4_184 VSS VDD VDD sky130_fd_sc_hd__fill_4
* cell instance sky130_fd_sc_hd__fill_4_185 r0 *1 0,0
Xsky130_fd_sc_hd__fill_4_185 VSS VDD VDD sky130_fd_sc_hd__fill_4
* cell instance sky130_fd_sc_hd__fill_4_186 r0 *1 0,0
Xsky130_fd_sc_hd__fill_4_186 VSS VDD VDD sky130_fd_sc_hd__fill_4
* cell instance sky130_fd_sc_hd__fill_4_187 r0 *1 0,0
Xsky130_fd_sc_hd__fill_4_187 VSS VDD VDD sky130_fd_sc_hd__fill_4
* cell instance sky130_fd_sc_hd__fill_4_188 r0 *1 0,0
Xsky130_fd_sc_hd__fill_4_188 VSS VDD VDD sky130_fd_sc_hd__fill_4
* cell instance sky130_fd_sc_hd__fill_4_189 r0 *1 0,0
Xsky130_fd_sc_hd__fill_4_189 VSS VDD VDD sky130_fd_sc_hd__fill_4
* cell instance sky130_fd_sc_hd__fill_4_190 r0 *1 0,0
Xsky130_fd_sc_hd__fill_4_190 VSS VDD VDD sky130_fd_sc_hd__fill_4
* cell instance sky130_fd_sc_hd__fill_4_191 r0 *1 0,0
Xsky130_fd_sc_hd__fill_4_191 VSS VDD VDD sky130_fd_sc_hd__fill_4
* cell instance sky130_fd_sc_hd__fill_4_192 r0 *1 0,0
Xsky130_fd_sc_hd__fill_4_192 VSS VDD VDD sky130_fd_sc_hd__fill_4
* cell instance sky130_fd_sc_hd__fill_4_193 r0 *1 0,0
Xsky130_fd_sc_hd__fill_4_193 VSS VDD VDD sky130_fd_sc_hd__fill_4
* cell instance sky130_fd_sc_hd__fill_4_194 r0 *1 0,0
Xsky130_fd_sc_hd__fill_4_194 VSS VDD VDD sky130_fd_sc_hd__fill_4
* cell instance sky130_fd_sc_hd__fill_4_195 r0 *1 0,0
Xsky130_fd_sc_hd__fill_4_195 VSS VDD VDD sky130_fd_sc_hd__fill_4
* cell instance sky130_fd_sc_hd__fill_4_196 r0 *1 0,0
Xsky130_fd_sc_hd__fill_4_196 VSS VDD VDD sky130_fd_sc_hd__fill_4
* cell instance sky130_fd_sc_hd__fill_4_197 r0 *1 0,0
Xsky130_fd_sc_hd__fill_4_197 VSS VDD VDD sky130_fd_sc_hd__fill_4
* cell instance sky130_fd_sc_hd__fill_4_198 r0 *1 0,0
Xsky130_fd_sc_hd__fill_4_198 VSS VDD VDD sky130_fd_sc_hd__fill_4
* cell instance sky130_fd_sc_hd__fill_4_199 r0 *1 0,0
Xsky130_fd_sc_hd__fill_4_199 VSS VDD VDD sky130_fd_sc_hd__fill_4
* cell instance sky130_fd_sc_hd__fill_4_200 r0 *1 0,0
Xsky130_fd_sc_hd__fill_4_200 VSS VDD VDD sky130_fd_sc_hd__fill_4
* cell instance sky130_fd_sc_hd__fill_4_201 r0 *1 0,0
Xsky130_fd_sc_hd__fill_4_201 VSS VDD VDD sky130_fd_sc_hd__fill_4
* cell instance sky130_fd_sc_hd__fill_4_202 r0 *1 0,0
Xsky130_fd_sc_hd__fill_4_202 VSS VDD VDD sky130_fd_sc_hd__fill_4
* cell instance sky130_fd_sc_hd__fill_4_203 r0 *1 0,0
Xsky130_fd_sc_hd__fill_4_203 VSS VDD VDD sky130_fd_sc_hd__fill_4
* cell instance sky130_fd_sc_hd__fill_4_204 r0 *1 0,0
Xsky130_fd_sc_hd__fill_4_204 VSS VDD VDD sky130_fd_sc_hd__fill_4
* cell instance sky130_fd_sc_hd__fill_4_205 r0 *1 0,0
Xsky130_fd_sc_hd__fill_4_205 VSS VDD VDD sky130_fd_sc_hd__fill_4
* cell instance sky130_fd_sc_hd__fill_4_206 r0 *1 0,0
Xsky130_fd_sc_hd__fill_4_206 VSS VDD VDD sky130_fd_sc_hd__fill_4
* cell instance sky130_fd_sc_hd__fill_4_207 r0 *1 0,0
Xsky130_fd_sc_hd__fill_4_207 VSS VDD VDD sky130_fd_sc_hd__fill_4
* cell instance sky130_fd_sc_hd__fill_4_208 r0 *1 0,0
Xsky130_fd_sc_hd__fill_4_208 VSS VDD VDD sky130_fd_sc_hd__fill_4
* cell instance sky130_fd_sc_hd__fill_4_209 r0 *1 0,0
Xsky130_fd_sc_hd__fill_4_209 VSS VDD VDD sky130_fd_sc_hd__fill_4
* cell instance sky130_fd_sc_hd__fill_4_210 r0 *1 0,0
Xsky130_fd_sc_hd__fill_4_210 VSS VDD VDD sky130_fd_sc_hd__fill_4
* cell instance sky130_fd_sc_hd__fill_4_211 r0 *1 0,0
Xsky130_fd_sc_hd__fill_4_211 VSS VDD VDD sky130_fd_sc_hd__fill_4
* cell instance sky130_fd_sc_hd__fill_4_212 r0 *1 0,0
Xsky130_fd_sc_hd__fill_4_212 VSS VDD VDD sky130_fd_sc_hd__fill_4
* cell instance sky130_fd_sc_hd__fill_4_213 r0 *1 0,0
Xsky130_fd_sc_hd__fill_4_213 VSS VDD VDD sky130_fd_sc_hd__fill_4
* cell instance sky130_fd_sc_hd__fill_4_214 r0 *1 0,0
Xsky130_fd_sc_hd__fill_4_214 VSS VDD VDD sky130_fd_sc_hd__fill_4
* cell instance sky130_fd_sc_hd__fill_4_215 r0 *1 0,0
Xsky130_fd_sc_hd__fill_4_215 VSS VDD VDD sky130_fd_sc_hd__fill_4
* cell instance sky130_fd_sc_hd__fill_4_216 r0 *1 0,0
Xsky130_fd_sc_hd__fill_4_216 VSS VDD VDD sky130_fd_sc_hd__fill_4
* cell instance sky130_fd_sc_hd__fill_4_217 r0 *1 0,0
Xsky130_fd_sc_hd__fill_4_217 VSS VDD VDD sky130_fd_sc_hd__fill_4
* cell instance sky130_fd_sc_hd__fill_4_218 r0 *1 0,0
Xsky130_fd_sc_hd__fill_4_218 VSS VDD VDD sky130_fd_sc_hd__fill_4
* cell instance sky130_fd_sc_hd__fill_4_219 r0 *1 0,0
Xsky130_fd_sc_hd__fill_4_219 VSS VDD VDD sky130_fd_sc_hd__fill_4
* cell instance sky130_fd_sc_hd__fill_4_220 r0 *1 0,0
Xsky130_fd_sc_hd__fill_4_220 VSS VDD VDD sky130_fd_sc_hd__fill_4
* cell instance sky130_fd_sc_hd__fill_4_221 r0 *1 0,0
Xsky130_fd_sc_hd__fill_4_221 VSS VDD VDD sky130_fd_sc_hd__fill_4
* cell instance sky130_fd_sc_hd__fill_4_222 r0 *1 0,0
Xsky130_fd_sc_hd__fill_4_222 VSS VDD VDD sky130_fd_sc_hd__fill_4
* cell instance sky130_fd_sc_hd__fill_4_223 r0 *1 0,0
Xsky130_fd_sc_hd__fill_4_223 VSS VDD VDD sky130_fd_sc_hd__fill_4
* cell instance sky130_fd_sc_hd__fill_4_224 r0 *1 0,0
Xsky130_fd_sc_hd__fill_4_224 VSS VDD VDD sky130_fd_sc_hd__fill_4
* cell instance sky130_fd_sc_hd__fill_4_225 r0 *1 0,0
Xsky130_fd_sc_hd__fill_4_225 VSS VDD VDD sky130_fd_sc_hd__fill_4
* cell instance sky130_fd_sc_hd__fill_4_226 r0 *1 0,0
Xsky130_fd_sc_hd__fill_4_226 VSS VDD VDD sky130_fd_sc_hd__fill_4
* cell instance sky130_fd_sc_hd__fill_4_227 r0 *1 0,0
Xsky130_fd_sc_hd__fill_4_227 VSS VDD VDD sky130_fd_sc_hd__fill_4
* cell instance sky130_fd_sc_hd__fill_4_228 r0 *1 0,0
Xsky130_fd_sc_hd__fill_4_228 VSS VDD VDD sky130_fd_sc_hd__fill_4
* cell instance sky130_fd_sc_hd__fill_4_229 r0 *1 0,0
Xsky130_fd_sc_hd__fill_4_229 VSS VDD VDD sky130_fd_sc_hd__fill_4
* cell instance sky130_fd_sc_hd__fill_4_230 r0 *1 0,0
Xsky130_fd_sc_hd__fill_4_230 VSS VDD VDD sky130_fd_sc_hd__fill_4
* cell instance sky130_fd_sc_hd__fill_4_231 r0 *1 0,0
Xsky130_fd_sc_hd__fill_4_231 VSS VDD VDD sky130_fd_sc_hd__fill_4
* cell instance sky130_fd_sc_hd__fill_4_232 r0 *1 0,0
Xsky130_fd_sc_hd__fill_4_232 VSS VDD VDD sky130_fd_sc_hd__fill_4
* cell instance sky130_fd_sc_hd__fill_4_233 r0 *1 0,0
Xsky130_fd_sc_hd__fill_4_233 VSS VDD VDD sky130_fd_sc_hd__fill_4
* cell instance sky130_fd_sc_hd__fill_4_234 r0 *1 0,0
Xsky130_fd_sc_hd__fill_4_234 VSS VDD VDD sky130_fd_sc_hd__fill_4
* cell instance sky130_fd_sc_hd__fill_4_235 r0 *1 0,0
Xsky130_fd_sc_hd__fill_4_235 VSS VDD VDD sky130_fd_sc_hd__fill_4
* cell instance sky130_fd_sc_hd__fill_4_236 r0 *1 0,0
Xsky130_fd_sc_hd__fill_4_236 VSS VDD VDD sky130_fd_sc_hd__fill_4
* cell instance sky130_fd_sc_hd__fill_4_237 r0 *1 0,0
Xsky130_fd_sc_hd__fill_4_237 VSS VDD VDD sky130_fd_sc_hd__fill_4
* cell instance sky130_fd_sc_hd__fill_4_238 r0 *1 0,0
Xsky130_fd_sc_hd__fill_4_238 VSS VDD VDD sky130_fd_sc_hd__fill_4
* cell instance sky130_fd_sc_hd__fill_4_239 r0 *1 0,0
Xsky130_fd_sc_hd__fill_4_239 VSS VDD VDD sky130_fd_sc_hd__fill_4
* cell instance sky130_fd_sc_hd__fill_4_240 r0 *1 0,0
Xsky130_fd_sc_hd__fill_4_240 VSS VDD VDD sky130_fd_sc_hd__fill_4
* cell instance sky130_fd_sc_hd__fill_4_241 r0 *1 0,0
Xsky130_fd_sc_hd__fill_4_241 VSS VDD VDD sky130_fd_sc_hd__fill_4
* cell instance sky130_fd_sc_hd__fill_4_242 r0 *1 0,0
Xsky130_fd_sc_hd__fill_4_242 VSS VDD VDD sky130_fd_sc_hd__fill_4
* cell instance sky130_fd_sc_hd__fill_4_243 r0 *1 0,0
Xsky130_fd_sc_hd__fill_4_243 VSS VDD VDD sky130_fd_sc_hd__fill_4
* cell instance sky130_fd_sc_hd__fill_4_244 r0 *1 0,0
Xsky130_fd_sc_hd__fill_4_244 VSS VDD VDD sky130_fd_sc_hd__fill_4
* cell instance sky130_fd_sc_hd__fill_4_245 r0 *1 0,0
Xsky130_fd_sc_hd__fill_4_245 VSS VDD VDD sky130_fd_sc_hd__fill_4
* cell instance sky130_fd_sc_hd__fill_4_246 r0 *1 0,0
Xsky130_fd_sc_hd__fill_4_246 VSS VDD VDD sky130_fd_sc_hd__fill_4
* cell instance sky130_fd_sc_hd__fill_4_247 r0 *1 0,0
Xsky130_fd_sc_hd__fill_4_247 VSS VDD VDD sky130_fd_sc_hd__fill_4
* cell instance sky130_fd_sc_hd__fill_4_248 r0 *1 0,0
Xsky130_fd_sc_hd__fill_4_248 VSS VDD VDD sky130_fd_sc_hd__fill_4
* cell instance sky130_fd_sc_hd__fill_4_249 r0 *1 0,0
Xsky130_fd_sc_hd__fill_4_249 VSS VDD VDD sky130_fd_sc_hd__fill_4
* cell instance sky130_fd_sc_hd__fill_4_250 r0 *1 0,0
Xsky130_fd_sc_hd__fill_4_250 VSS VDD VDD sky130_fd_sc_hd__fill_4
* cell instance sky130_fd_sc_hd__fill_4_251 r0 *1 0,0
Xsky130_fd_sc_hd__fill_4_251 VSS VDD VDD sky130_fd_sc_hd__fill_4
* cell instance sky130_fd_sc_hd__fill_4_252 r0 *1 0,0
Xsky130_fd_sc_hd__fill_4_252 VSS VDD VDD sky130_fd_sc_hd__fill_4
* cell instance sky130_fd_sc_hd__fill_4_253 r0 *1 0,0
Xsky130_fd_sc_hd__fill_4_253 VSS VDD VDD sky130_fd_sc_hd__fill_4
* cell instance sky130_fd_sc_hd__fill_4_254 r0 *1 0,0
Xsky130_fd_sc_hd__fill_4_254 VSS VDD VDD sky130_fd_sc_hd__fill_4
* cell instance sky130_fd_sc_hd__fill_4_255 r0 *1 0,0
Xsky130_fd_sc_hd__fill_4_255 VSS VDD VDD sky130_fd_sc_hd__fill_4
* cell instance sky130_fd_sc_hd__fill_4_256 r0 *1 0,0
Xsky130_fd_sc_hd__fill_4_256 VSS VDD VDD sky130_fd_sc_hd__fill_4
* cell instance sky130_fd_sc_hd__fill_4_257 r0 *1 0,0
Xsky130_fd_sc_hd__fill_4_257 VSS VDD VDD sky130_fd_sc_hd__fill_4
* cell instance sky130_fd_sc_hd__fill_4_258 r0 *1 0,0
Xsky130_fd_sc_hd__fill_4_258 VSS VDD VDD sky130_fd_sc_hd__fill_4
* cell instance sky130_fd_sc_hd__fill_4_259 r0 *1 0,0
Xsky130_fd_sc_hd__fill_4_259 VSS VDD VDD sky130_fd_sc_hd__fill_4
* cell instance sky130_fd_sc_hd__fill_4_260 r0 *1 0,0
Xsky130_fd_sc_hd__fill_4_260 VSS VDD VDD sky130_fd_sc_hd__fill_4
* cell instance sky130_fd_sc_hd__fill_4_261 r0 *1 0,0
Xsky130_fd_sc_hd__fill_4_261 VSS VDD VDD sky130_fd_sc_hd__fill_4
* cell instance sky130_fd_sc_hd__fill_4_262 r0 *1 0,0
Xsky130_fd_sc_hd__fill_4_262 VSS VDD VDD sky130_fd_sc_hd__fill_4
* cell instance sky130_fd_sc_hd__fill_4_263 r0 *1 0,0
Xsky130_fd_sc_hd__fill_4_263 VSS VDD VDD sky130_fd_sc_hd__fill_4
* cell instance sky130_fd_sc_hd__fill_4_264 r0 *1 0,0
Xsky130_fd_sc_hd__fill_4_264 VSS VDD VDD sky130_fd_sc_hd__fill_4
* cell instance sky130_fd_sc_hd__fill_4_265 r0 *1 0,0
Xsky130_fd_sc_hd__fill_4_265 VSS VDD VDD sky130_fd_sc_hd__fill_4
* cell instance sky130_fd_sc_hd__fill_4_266 r0 *1 0,0
Xsky130_fd_sc_hd__fill_4_266 VSS VDD VDD sky130_fd_sc_hd__fill_4
* cell instance sky130_fd_sc_hd__fill_4_267 r0 *1 0,0
Xsky130_fd_sc_hd__fill_4_267 VSS VDD VDD sky130_fd_sc_hd__fill_4
* cell instance sky130_fd_sc_hd__fill_4_268 r0 *1 0,0
Xsky130_fd_sc_hd__fill_4_268 VSS VDD VDD sky130_fd_sc_hd__fill_4
* cell instance sky130_fd_sc_hd__fill_4_269 r0 *1 0,0
Xsky130_fd_sc_hd__fill_4_269 VSS VDD VDD sky130_fd_sc_hd__fill_4
* cell instance sky130_fd_sc_hd__fill_4_270 r0 *1 0,0
Xsky130_fd_sc_hd__fill_4_270 VSS VDD VDD sky130_fd_sc_hd__fill_4
* cell instance sky130_fd_sc_hd__fill_4_271 r0 *1 0,0
Xsky130_fd_sc_hd__fill_4_271 VSS VDD VDD sky130_fd_sc_hd__fill_4
* cell instance sky130_fd_sc_hd__fill_4_272 r0 *1 0,0
Xsky130_fd_sc_hd__fill_4_272 VSS VDD VDD sky130_fd_sc_hd__fill_4
* cell instance sky130_fd_sc_hd__fill_4_273 r0 *1 0,0
Xsky130_fd_sc_hd__fill_4_273 VSS VDD VDD sky130_fd_sc_hd__fill_4
* cell instance sky130_fd_sc_hd__fill_4_274 r0 *1 0,0
Xsky130_fd_sc_hd__fill_4_274 VSS VDD VDD sky130_fd_sc_hd__fill_4
* cell instance sky130_fd_sc_hd__fill_4_275 r0 *1 0,0
Xsky130_fd_sc_hd__fill_4_275 VSS VDD VDD sky130_fd_sc_hd__fill_4
* cell instance sky130_fd_sc_hd__fill_4_276 r0 *1 0,0
Xsky130_fd_sc_hd__fill_4_276 VSS VDD VDD sky130_fd_sc_hd__fill_4
* cell instance sky130_fd_sc_hd__fill_4_277 r0 *1 0,0
Xsky130_fd_sc_hd__fill_4_277 VSS VDD VDD sky130_fd_sc_hd__fill_4
* cell instance sky130_fd_sc_hd__fill_4_278 r0 *1 0,0
Xsky130_fd_sc_hd__fill_4_278 VSS VDD VDD sky130_fd_sc_hd__fill_4
* cell instance sky130_fd_sc_hd__fill_4_279 r0 *1 0,0
Xsky130_fd_sc_hd__fill_4_279 VSS VDD VDD sky130_fd_sc_hd__fill_4
* cell instance sky130_fd_sc_hd__fill_4_280 r0 *1 0,0
Xsky130_fd_sc_hd__fill_4_280 VSS VDD VDD sky130_fd_sc_hd__fill_4
* cell instance sky130_fd_sc_hd__fill_4_281 r0 *1 0,0
Xsky130_fd_sc_hd__fill_4_281 VSS VDD VDD sky130_fd_sc_hd__fill_4
* cell instance sky130_fd_sc_hd__fill_4_282 r0 *1 0,0
Xsky130_fd_sc_hd__fill_4_282 VSS VDD VDD sky130_fd_sc_hd__fill_4
* cell instance sky130_fd_sc_hd__fill_4_283 r0 *1 0,0
Xsky130_fd_sc_hd__fill_4_283 VSS VDD VDD sky130_fd_sc_hd__fill_4
* cell instance sky130_fd_sc_hd__fill_4_284 r0 *1 0,0
Xsky130_fd_sc_hd__fill_4_284 VSS VDD VDD sky130_fd_sc_hd__fill_4
* cell instance sky130_fd_sc_hd__fill_4_285 r0 *1 0,0
Xsky130_fd_sc_hd__fill_4_285 VSS VDD VDD sky130_fd_sc_hd__fill_4
* cell instance sky130_fd_sc_hd__fill_4_286 r0 *1 0,0
Xsky130_fd_sc_hd__fill_4_286 VSS VDD VDD sky130_fd_sc_hd__fill_4
* cell instance sky130_fd_sc_hd__fill_4_287 r0 *1 0,0
Xsky130_fd_sc_hd__fill_4_287 VSS VDD VDD sky130_fd_sc_hd__fill_4
* cell instance sky130_fd_sc_hd__fill_4_288 r0 *1 0,0
Xsky130_fd_sc_hd__fill_4_288 VSS VDD VDD sky130_fd_sc_hd__fill_4
* cell instance sky130_fd_sc_hd__fill_4_289 r0 *1 0,0
Xsky130_fd_sc_hd__fill_4_289 VSS VDD VDD sky130_fd_sc_hd__fill_4
* cell instance sky130_fd_sc_hd__fill_4_290 r0 *1 0,0
Xsky130_fd_sc_hd__fill_4_290 VSS VDD VDD sky130_fd_sc_hd__fill_4
* cell instance sky130_fd_sc_hd__fill_4_291 r0 *1 0,0
Xsky130_fd_sc_hd__fill_4_291 VSS VDD VDD sky130_fd_sc_hd__fill_4
* cell instance sky130_fd_sc_hd__fill_4_292 r0 *1 0,0
Xsky130_fd_sc_hd__fill_4_292 VSS VDD VDD sky130_fd_sc_hd__fill_4
* cell instance sky130_fd_sc_hd__fill_4_293 r0 *1 0,0
Xsky130_fd_sc_hd__fill_4_293 VSS VDD VDD sky130_fd_sc_hd__fill_4
* cell instance sky130_fd_sc_hd__fill_4_294 r0 *1 0,0
Xsky130_fd_sc_hd__fill_4_294 VSS VDD VDD sky130_fd_sc_hd__fill_4
* cell instance sky130_fd_sc_hd__fill_4_295 r0 *1 0,0
Xsky130_fd_sc_hd__fill_4_295 VSS VDD VDD sky130_fd_sc_hd__fill_4
* cell instance sky130_fd_sc_hd__fill_4_296 r0 *1 0,0
Xsky130_fd_sc_hd__fill_4_296 VSS VDD VDD sky130_fd_sc_hd__fill_4
* cell instance sky130_fd_sc_hd__fill_4_297 r0 *1 0,0
Xsky130_fd_sc_hd__fill_4_297 VSS VDD VDD sky130_fd_sc_hd__fill_4
* cell instance sky130_fd_sc_hd__fill_4_298 r0 *1 0,0
Xsky130_fd_sc_hd__fill_4_298 VSS VDD VDD sky130_fd_sc_hd__fill_4
* cell instance sky130_fd_sc_hd__fill_4_299 r0 *1 0,0
Xsky130_fd_sc_hd__fill_4_299 VSS VDD VDD sky130_fd_sc_hd__fill_4
* cell instance sky130_fd_sc_hd__fill_4_300 r0 *1 0,0
Xsky130_fd_sc_hd__fill_4_300 VSS VDD VDD sky130_fd_sc_hd__fill_4
* cell instance sky130_fd_sc_hd__fill_4_301 r0 *1 0,0
Xsky130_fd_sc_hd__fill_4_301 VSS VDD VDD sky130_fd_sc_hd__fill_4
* cell instance sky130_fd_sc_hd__fill_4_302 r0 *1 0,0
Xsky130_fd_sc_hd__fill_4_302 VSS VDD VDD sky130_fd_sc_hd__fill_4
* cell instance sky130_fd_sc_hd__fill_4_303 r0 *1 0,0
Xsky130_fd_sc_hd__fill_4_303 VSS VDD VDD sky130_fd_sc_hd__fill_4
* cell instance sky130_fd_sc_hd__fill_4_304 r0 *1 0,0
Xsky130_fd_sc_hd__fill_4_304 VSS VDD VDD sky130_fd_sc_hd__fill_4
* cell instance sky130_fd_sc_hd__fill_4_305 r0 *1 0,0
Xsky130_fd_sc_hd__fill_4_305 VSS VDD VDD sky130_fd_sc_hd__fill_4
* cell instance sky130_fd_sc_hd__fill_4_306 r0 *1 0,0
Xsky130_fd_sc_hd__fill_4_306 VSS VDD VDD sky130_fd_sc_hd__fill_4
* cell instance sky130_fd_sc_hd__fill_4_307 r0 *1 0,0
Xsky130_fd_sc_hd__fill_4_307 VSS VDD VDD sky130_fd_sc_hd__fill_4
* cell instance sky130_fd_sc_hd__fill_4_308 r0 *1 0,0
Xsky130_fd_sc_hd__fill_4_308 VSS VDD VDD sky130_fd_sc_hd__fill_4
* cell instance sky130_fd_sc_hd__fill_4_309 r0 *1 0,0
Xsky130_fd_sc_hd__fill_4_309 VSS VDD VDD sky130_fd_sc_hd__fill_4
* cell instance sky130_fd_sc_hd__fill_4_310 r0 *1 0,0
Xsky130_fd_sc_hd__fill_4_310 VSS VDD VDD sky130_fd_sc_hd__fill_4
* cell instance sky130_fd_sc_hd__fill_4_311 r0 *1 0,0
Xsky130_fd_sc_hd__fill_4_311 VSS VDD VDD sky130_fd_sc_hd__fill_4
* cell instance sky130_fd_sc_hd__fill_4_312 r0 *1 0,0
Xsky130_fd_sc_hd__fill_4_312 VSS VDD VDD sky130_fd_sc_hd__fill_4
* cell instance sky130_fd_sc_hd__fill_4_313 r0 *1 0,0
Xsky130_fd_sc_hd__fill_4_313 VSS VDD VDD sky130_fd_sc_hd__fill_4
* cell instance sky130_fd_sc_hd__fill_4_314 r0 *1 0,0
Xsky130_fd_sc_hd__fill_4_314 VSS VDD VDD sky130_fd_sc_hd__fill_4
* cell instance sky130_fd_sc_hd__fill_4_315 r0 *1 0,0
Xsky130_fd_sc_hd__fill_4_315 VSS VDD VDD sky130_fd_sc_hd__fill_4
* cell instance sky130_fd_sc_hd__fill_4_316 r0 *1 0,0
Xsky130_fd_sc_hd__fill_4_316 VSS VDD VDD sky130_fd_sc_hd__fill_4
* cell instance sky130_fd_sc_hd__fill_4_317 r0 *1 0,0
Xsky130_fd_sc_hd__fill_4_317 VSS VDD VDD sky130_fd_sc_hd__fill_4
* cell instance sky130_fd_sc_hd__fill_4_318 r0 *1 0,0
Xsky130_fd_sc_hd__fill_4_318 VSS VDD VDD sky130_fd_sc_hd__fill_4
* cell instance sky130_fd_sc_hd__fill_4_319 r0 *1 0,0
Xsky130_fd_sc_hd__fill_4_319 VSS VDD VDD sky130_fd_sc_hd__fill_4
* cell instance sky130_fd_sc_hd__fill_4_320 r0 *1 0,0
Xsky130_fd_sc_hd__fill_4_320 VSS VDD VDD sky130_fd_sc_hd__fill_4
* cell instance sky130_fd_sc_hd__fill_4_321 r0 *1 0,0
Xsky130_fd_sc_hd__fill_4_321 VSS VDD VDD sky130_fd_sc_hd__fill_4
* cell instance sky130_fd_sc_hd__fill_4_322 r0 *1 0,0
Xsky130_fd_sc_hd__fill_4_322 VSS VDD VDD sky130_fd_sc_hd__fill_4
* cell instance sky130_fd_sc_hd__fill_4_323 r0 *1 0,0
Xsky130_fd_sc_hd__fill_4_323 VSS VDD VDD sky130_fd_sc_hd__fill_4
* cell instance sky130_fd_sc_hd__fill_4_324 r0 *1 0,0
Xsky130_fd_sc_hd__fill_4_324 VSS VDD VDD sky130_fd_sc_hd__fill_4
* cell instance sky130_fd_sc_hd__fill_4_325 r0 *1 0,0
Xsky130_fd_sc_hd__fill_4_325 VSS VDD VDD sky130_fd_sc_hd__fill_4
* cell instance sky130_fd_sc_hd__fill_4_326 r0 *1 0,0
Xsky130_fd_sc_hd__fill_4_326 VSS VDD VDD sky130_fd_sc_hd__fill_4
* cell instance sky130_fd_sc_hd__fill_4_327 r0 *1 0,0
Xsky130_fd_sc_hd__fill_4_327 VSS VDD VDD sky130_fd_sc_hd__fill_4
* cell instance sky130_fd_sc_hd__fill_4_328 r0 *1 0,0
Xsky130_fd_sc_hd__fill_4_328 VSS VDD VDD sky130_fd_sc_hd__fill_4
* cell instance sky130_fd_sc_hd__fill_4_329 r0 *1 0,0
Xsky130_fd_sc_hd__fill_4_329 VSS VDD VDD sky130_fd_sc_hd__fill_4
* cell instance sky130_fd_sc_hd__fill_4_330 r0 *1 0,0
Xsky130_fd_sc_hd__fill_4_330 VSS VDD VDD sky130_fd_sc_hd__fill_4
* cell instance sky130_fd_sc_hd__fill_4_331 r0 *1 0,0
Xsky130_fd_sc_hd__fill_4_331 VSS VDD VDD sky130_fd_sc_hd__fill_4
* cell instance sky130_fd_sc_hd__fill_4_332 r0 *1 0,0
Xsky130_fd_sc_hd__fill_4_332 VSS VDD VDD sky130_fd_sc_hd__fill_4
* cell instance sky130_fd_sc_hd__fill_4_333 r0 *1 0,0
Xsky130_fd_sc_hd__fill_4_333 VSS VDD VDD sky130_fd_sc_hd__fill_4
* cell instance sky130_fd_sc_hd__fill_4_334 r0 *1 0,0
Xsky130_fd_sc_hd__fill_4_334 VSS VDD VDD sky130_fd_sc_hd__fill_4
* cell instance sky130_fd_sc_hd__fill_4_335 r0 *1 0,0
Xsky130_fd_sc_hd__fill_4_335 VSS VDD VDD sky130_fd_sc_hd__fill_4
* cell instance sky130_fd_sc_hd__fill_4_336 r0 *1 0,0
Xsky130_fd_sc_hd__fill_4_336 VSS VDD VDD sky130_fd_sc_hd__fill_4
* cell instance sky130_fd_sc_hd__fill_4_337 r0 *1 0,0
Xsky130_fd_sc_hd__fill_4_337 VSS VDD VDD sky130_fd_sc_hd__fill_4
* cell instance sky130_fd_sc_hd__fill_4_338 r0 *1 0,0
Xsky130_fd_sc_hd__fill_4_338 VSS VDD VDD sky130_fd_sc_hd__fill_4
* cell instance sky130_fd_sc_hd__fill_4_339 r0 *1 0,0
Xsky130_fd_sc_hd__fill_4_339 VSS VDD VDD sky130_fd_sc_hd__fill_4
* cell instance sky130_fd_sc_hd__fill_4_340 r0 *1 0,0
Xsky130_fd_sc_hd__fill_4_340 VSS VDD VDD sky130_fd_sc_hd__fill_4
* cell instance sky130_fd_sc_hd__fill_4_341 r0 *1 0,0
Xsky130_fd_sc_hd__fill_4_341 VSS VDD VDD sky130_fd_sc_hd__fill_4
* cell instance sky130_fd_sc_hd__fill_4_342 r0 *1 0,0
Xsky130_fd_sc_hd__fill_4_342 VSS VDD VDD sky130_fd_sc_hd__fill_4
* cell instance sky130_fd_sc_hd__fill_4_343 r0 *1 0,0
Xsky130_fd_sc_hd__fill_4_343 VSS VDD VDD sky130_fd_sc_hd__fill_4
* cell instance sky130_fd_sc_hd__fill_4_344 r0 *1 0,0
Xsky130_fd_sc_hd__fill_4_344 VSS VDD VDD sky130_fd_sc_hd__fill_4
* cell instance sky130_fd_sc_hd__fill_4_345 r0 *1 0,0
Xsky130_fd_sc_hd__fill_4_345 VSS VDD VDD sky130_fd_sc_hd__fill_4
* cell instance sky130_fd_sc_hd__fill_4_346 r0 *1 0,0
Xsky130_fd_sc_hd__fill_4_346 VSS VDD VDD sky130_fd_sc_hd__fill_4
* cell instance sky130_fd_sc_hd__fill_4_347 r0 *1 0,0
Xsky130_fd_sc_hd__fill_4_347 VSS VDD VDD sky130_fd_sc_hd__fill_4
* cell instance sky130_fd_sc_hd__fill_4_348 r0 *1 0,0
Xsky130_fd_sc_hd__fill_4_348 VSS VDD VDD sky130_fd_sc_hd__fill_4
* cell instance sky130_fd_sc_hd__fill_4_349 r0 *1 0,0
Xsky130_fd_sc_hd__fill_4_349 VSS VDD VDD sky130_fd_sc_hd__fill_4
* cell instance sky130_fd_sc_hd__fill_4_350 r0 *1 0,0
Xsky130_fd_sc_hd__fill_4_350 VSS VDD VDD sky130_fd_sc_hd__fill_4
* cell instance sky130_fd_sc_hd__fill_4_351 r0 *1 0,0
Xsky130_fd_sc_hd__fill_4_351 VSS VDD VDD sky130_fd_sc_hd__fill_4
* cell instance sky130_fd_sc_hd__fill_4_352 r0 *1 0,0
Xsky130_fd_sc_hd__fill_4_352 VSS VDD VDD sky130_fd_sc_hd__fill_4
* cell instance sky130_fd_sc_hd__fill_4_353 r0 *1 0,0
Xsky130_fd_sc_hd__fill_4_353 VSS VDD VDD sky130_fd_sc_hd__fill_4
* cell instance sky130_fd_sc_hd__fill_4_354 r0 *1 0,0
Xsky130_fd_sc_hd__fill_4_354 VSS VDD VDD sky130_fd_sc_hd__fill_4
* cell instance sky130_fd_sc_hd__fill_4_355 r0 *1 0,0
Xsky130_fd_sc_hd__fill_4_355 VSS VDD VDD sky130_fd_sc_hd__fill_4
* cell instance sky130_fd_sc_hd__fill_4_356 r0 *1 0,0
Xsky130_fd_sc_hd__fill_4_356 VSS VDD VDD sky130_fd_sc_hd__fill_4
* cell instance sky130_fd_sc_hd__fill_4_357 r0 *1 0,0
Xsky130_fd_sc_hd__fill_4_357 VSS VDD VDD sky130_fd_sc_hd__fill_4
* cell instance sky130_fd_sc_hd__fill_4_358 r0 *1 0,0
Xsky130_fd_sc_hd__fill_4_358 VSS VDD VDD sky130_fd_sc_hd__fill_4
* cell instance sky130_fd_sc_hd__fill_4_359 r0 *1 0,0
Xsky130_fd_sc_hd__fill_4_359 VSS VDD VDD sky130_fd_sc_hd__fill_4
* cell instance sky130_fd_sc_hd__fill_4_360 r0 *1 0,0
Xsky130_fd_sc_hd__fill_4_360 VSS VDD VDD sky130_fd_sc_hd__fill_4
* cell instance sky130_fd_sc_hd__fill_4_361 r0 *1 0,0
Xsky130_fd_sc_hd__fill_4_361 VSS VDD VDD sky130_fd_sc_hd__fill_4
* cell instance sky130_fd_sc_hd__fill_4_362 r0 *1 0,0
Xsky130_fd_sc_hd__fill_4_362 VSS VDD VDD sky130_fd_sc_hd__fill_4
* cell instance sky130_fd_sc_hd__fill_4_363 r0 *1 0,0
Xsky130_fd_sc_hd__fill_4_363 VSS VDD VDD sky130_fd_sc_hd__fill_4
* cell instance sky130_fd_sc_hd__fill_4_364 r0 *1 0,0
Xsky130_fd_sc_hd__fill_4_364 VSS VDD VDD sky130_fd_sc_hd__fill_4
* cell instance sky130_fd_sc_hd__fill_4_365 r0 *1 0,0
Xsky130_fd_sc_hd__fill_4_365 VSS VDD VDD sky130_fd_sc_hd__fill_4
* cell instance sky130_fd_sc_hd__fill_4_366 r0 *1 0,0
Xsky130_fd_sc_hd__fill_4_366 VSS VDD VDD sky130_fd_sc_hd__fill_4
* cell instance sky130_fd_sc_hd__fill_4_367 r0 *1 0,0
Xsky130_fd_sc_hd__fill_4_367 VSS VDD VDD sky130_fd_sc_hd__fill_4
* cell instance sky130_fd_sc_hd__fill_4_368 r0 *1 0,0
Xsky130_fd_sc_hd__fill_4_368 VSS VDD VDD sky130_fd_sc_hd__fill_4
* cell instance sky130_fd_sc_hd__fill_4_369 r0 *1 0,0
Xsky130_fd_sc_hd__fill_4_369 VSS VDD VDD sky130_fd_sc_hd__fill_4
* cell instance sky130_fd_sc_hd__fill_4_370 r0 *1 0,0
Xsky130_fd_sc_hd__fill_4_370 VSS VDD VDD sky130_fd_sc_hd__fill_4
* cell instance sky130_fd_sc_hd__fill_4_371 r0 *1 0,0
Xsky130_fd_sc_hd__fill_4_371 VSS VDD VDD sky130_fd_sc_hd__fill_4
* cell instance sky130_fd_sc_hd__fill_4_372 r0 *1 0,0
Xsky130_fd_sc_hd__fill_4_372 VSS VDD VDD sky130_fd_sc_hd__fill_4
* cell instance sky130_fd_sc_hd__fill_4_373 r0 *1 0,0
Xsky130_fd_sc_hd__fill_4_373 VSS VDD VDD sky130_fd_sc_hd__fill_4
* cell instance sky130_fd_sc_hd__fill_4_374 r0 *1 0,0
Xsky130_fd_sc_hd__fill_4_374 VSS VDD VDD sky130_fd_sc_hd__fill_4
* cell instance sky130_fd_sc_hd__fill_4_375 r0 *1 0,0
Xsky130_fd_sc_hd__fill_4_375 VSS VDD VDD sky130_fd_sc_hd__fill_4
* cell instance sky130_fd_sc_hd__fill_4_376 r0 *1 0,0
Xsky130_fd_sc_hd__fill_4_376 VSS VDD VDD sky130_fd_sc_hd__fill_4
* cell instance sky130_fd_sc_hd__fill_4_377 r0 *1 0,0
Xsky130_fd_sc_hd__fill_4_377 VSS VDD VDD sky130_fd_sc_hd__fill_4
* cell instance sky130_fd_sc_hd__fill_4_378 r0 *1 0,0
Xsky130_fd_sc_hd__fill_4_378 VSS VDD VDD sky130_fd_sc_hd__fill_4
* cell instance sky130_fd_sc_hd__fill_4_379 r0 *1 0,0
Xsky130_fd_sc_hd__fill_4_379 VSS VDD VDD sky130_fd_sc_hd__fill_4
* cell instance sky130_fd_sc_hd__fill_4_380 r0 *1 0,0
Xsky130_fd_sc_hd__fill_4_380 VSS VDD VDD sky130_fd_sc_hd__fill_4
* cell instance sky130_fd_sc_hd__fill_4_381 r0 *1 0,0
Xsky130_fd_sc_hd__fill_4_381 VSS VDD VDD sky130_fd_sc_hd__fill_4
* cell instance sky130_fd_sc_hd__fill_4_382 r0 *1 0,0
Xsky130_fd_sc_hd__fill_4_382 VSS VDD VDD sky130_fd_sc_hd__fill_4
* cell instance sky130_fd_sc_hd__fill_4_383 r0 *1 0,0
Xsky130_fd_sc_hd__fill_4_383 VSS VDD VDD sky130_fd_sc_hd__fill_4
* cell instance sky130_fd_sc_hd__fill_4_384 r0 *1 0,0
Xsky130_fd_sc_hd__fill_4_384 VSS VDD VDD sky130_fd_sc_hd__fill_4
* cell instance sky130_fd_sc_hd__fill_4_385 r0 *1 0,0
Xsky130_fd_sc_hd__fill_4_385 VSS VDD VDD sky130_fd_sc_hd__fill_4
* cell instance sky130_fd_sc_hd__fill_4_386 r0 *1 0,0
Xsky130_fd_sc_hd__fill_4_386 VSS VDD VDD sky130_fd_sc_hd__fill_4
* cell instance sky130_fd_sc_hd__fill_4_387 r0 *1 0,0
Xsky130_fd_sc_hd__fill_4_387 VSS VDD VDD sky130_fd_sc_hd__fill_4
* cell instance sky130_fd_sc_hd__fill_4_388 r0 *1 0,0
Xsky130_fd_sc_hd__fill_4_388 VSS VDD VDD sky130_fd_sc_hd__fill_4
* cell instance sky130_fd_sc_hd__fill_4_389 r0 *1 0,0
Xsky130_fd_sc_hd__fill_4_389 VSS VDD VDD sky130_fd_sc_hd__fill_4
* cell instance sky130_fd_sc_hd__fill_4_390 r0 *1 0,0
Xsky130_fd_sc_hd__fill_4_390 VSS VDD VDD sky130_fd_sc_hd__fill_4
* cell instance sky130_fd_sc_hd__fill_4_391 r0 *1 0,0
Xsky130_fd_sc_hd__fill_4_391 VSS VDD VDD sky130_fd_sc_hd__fill_4
* cell instance sky130_fd_sc_hd__fill_4_392 r0 *1 0,0
Xsky130_fd_sc_hd__fill_4_392 VSS VDD VDD sky130_fd_sc_hd__fill_4
* cell instance sky130_fd_sc_hd__fill_4_393 r0 *1 0,0
Xsky130_fd_sc_hd__fill_4_393 VSS VDD VDD sky130_fd_sc_hd__fill_4
* cell instance sky130_fd_sc_hd__fill_4_394 r0 *1 0,0
Xsky130_fd_sc_hd__fill_4_394 VSS VDD VDD sky130_fd_sc_hd__fill_4
* cell instance sky130_fd_sc_hd__fill_4_395 r0 *1 0,0
Xsky130_fd_sc_hd__fill_4_395 VSS VDD VDD sky130_fd_sc_hd__fill_4
* cell instance sky130_fd_sc_hd__fill_4_396 r0 *1 0,0
Xsky130_fd_sc_hd__fill_4_396 VSS VDD VDD sky130_fd_sc_hd__fill_4
* cell instance sky130_fd_sc_hd__fill_4_397 r0 *1 0,0
Xsky130_fd_sc_hd__fill_4_397 VSS VDD VDD sky130_fd_sc_hd__fill_4
* cell instance sky130_fd_sc_hd__fill_4_398 r0 *1 0,0
Xsky130_fd_sc_hd__fill_4_398 VSS VDD VDD sky130_fd_sc_hd__fill_4
* cell instance sky130_fd_sc_hd__fill_4_399 r0 *1 0,0
Xsky130_fd_sc_hd__fill_4_399 VSS VDD VDD sky130_fd_sc_hd__fill_4
* cell instance sky130_fd_sc_hd__fill_4_400 r0 *1 0,0
Xsky130_fd_sc_hd__fill_4_400 VSS VDD VDD sky130_fd_sc_hd__fill_4
* cell instance sky130_fd_sc_hd__fill_4_401 r0 *1 0,0
Xsky130_fd_sc_hd__fill_4_401 VSS VDD VDD sky130_fd_sc_hd__fill_4
* cell instance sky130_fd_sc_hd__fill_4_402 r0 *1 0,0
Xsky130_fd_sc_hd__fill_4_402 VSS VDD VDD sky130_fd_sc_hd__fill_4
* cell instance sky130_fd_sc_hd__fill_4_403 r0 *1 0,0
Xsky130_fd_sc_hd__fill_4_403 VSS VDD VDD sky130_fd_sc_hd__fill_4
* cell instance sky130_fd_sc_hd__fill_4_404 r0 *1 0,0
Xsky130_fd_sc_hd__fill_4_404 VSS VDD VDD sky130_fd_sc_hd__fill_4
* cell instance sky130_fd_sc_hd__fill_4_405 r0 *1 0,0
Xsky130_fd_sc_hd__fill_4_405 VSS VDD VDD sky130_fd_sc_hd__fill_4
* cell instance sky130_fd_sc_hd__fill_4_406 r0 *1 0,0
Xsky130_fd_sc_hd__fill_4_406 VSS VDD VDD sky130_fd_sc_hd__fill_4
* cell instance sky130_fd_sc_hd__fill_4_407 r0 *1 0,0
Xsky130_fd_sc_hd__fill_4_407 VSS VDD VDD sky130_fd_sc_hd__fill_4
* cell instance sky130_fd_sc_hd__fill_4_408 r0 *1 0,0
Xsky130_fd_sc_hd__fill_4_408 VSS VDD VDD sky130_fd_sc_hd__fill_4
* cell instance sky130_fd_sc_hd__fill_4_409 r0 *1 0,0
Xsky130_fd_sc_hd__fill_4_409 VSS VDD VDD sky130_fd_sc_hd__fill_4
* cell instance sky130_fd_sc_hd__fill_4_410 r0 *1 0,0
Xsky130_fd_sc_hd__fill_4_410 VSS VDD VDD sky130_fd_sc_hd__fill_4
* cell instance sky130_fd_sc_hd__fill_4_411 r0 *1 0,0
Xsky130_fd_sc_hd__fill_4_411 VSS VDD VDD sky130_fd_sc_hd__fill_4
* cell instance sky130_fd_sc_hd__fill_4_412 r0 *1 0,0
Xsky130_fd_sc_hd__fill_4_412 VSS VDD VDD sky130_fd_sc_hd__fill_4
* cell instance sky130_fd_sc_hd__fill_4_413 r0 *1 0,0
Xsky130_fd_sc_hd__fill_4_413 VSS VDD VDD sky130_fd_sc_hd__fill_4
* cell instance sky130_fd_sc_hd__fill_4_414 r0 *1 0,0
Xsky130_fd_sc_hd__fill_4_414 VSS VDD VDD sky130_fd_sc_hd__fill_4
* cell instance sky130_fd_sc_hd__fill_4_415 r0 *1 0,0
Xsky130_fd_sc_hd__fill_4_415 VSS VDD VDD sky130_fd_sc_hd__fill_4
* cell instance sky130_fd_sc_hd__fill_4_416 r0 *1 0,0
Xsky130_fd_sc_hd__fill_4_416 VSS VDD VDD sky130_fd_sc_hd__fill_4
* cell instance sky130_fd_sc_hd__fill_4_417 r0 *1 0,0
Xsky130_fd_sc_hd__fill_4_417 VSS VDD VDD sky130_fd_sc_hd__fill_4
* cell instance sky130_fd_sc_hd__fill_4_418 r0 *1 0,0
Xsky130_fd_sc_hd__fill_4_418 VSS VDD VDD sky130_fd_sc_hd__fill_4
* cell instance sky130_fd_sc_hd__fill_4_419 r0 *1 0,0
Xsky130_fd_sc_hd__fill_4_419 VSS VDD VDD sky130_fd_sc_hd__fill_4
* cell instance sky130_fd_sc_hd__fill_4_420 r0 *1 0,0
Xsky130_fd_sc_hd__fill_4_420 VSS VDD VDD sky130_fd_sc_hd__fill_4
* cell instance sky130_fd_sc_hd__fill_4_421 r0 *1 0,0
Xsky130_fd_sc_hd__fill_4_421 VSS VDD VDD sky130_fd_sc_hd__fill_4
* cell instance sky130_fd_sc_hd__fill_4_422 r0 *1 0,0
Xsky130_fd_sc_hd__fill_4_422 VSS VDD VDD sky130_fd_sc_hd__fill_4
* cell instance sky130_fd_sc_hd__fill_4_423 r0 *1 0,0
Xsky130_fd_sc_hd__fill_4_423 VSS VDD VDD sky130_fd_sc_hd__fill_4
* cell instance sky130_fd_sc_hd__fill_4_424 r0 *1 0,0
Xsky130_fd_sc_hd__fill_4_424 VSS VDD VDD sky130_fd_sc_hd__fill_4
* cell instance sky130_fd_sc_hd__fill_4_425 r0 *1 0,0
Xsky130_fd_sc_hd__fill_4_425 VSS VDD VDD sky130_fd_sc_hd__fill_4
* cell instance sky130_fd_sc_hd__fill_4_426 r0 *1 0,0
Xsky130_fd_sc_hd__fill_4_426 VSS VDD VDD sky130_fd_sc_hd__fill_4
* cell instance sky130_fd_sc_hd__fill_4_427 r0 *1 0,0
Xsky130_fd_sc_hd__fill_4_427 VSS VDD VDD sky130_fd_sc_hd__fill_4
* cell instance sky130_fd_sc_hd__fill_4_428 r0 *1 0,0
Xsky130_fd_sc_hd__fill_4_428 VSS VDD VDD sky130_fd_sc_hd__fill_4
* cell instance sky130_fd_sc_hd__fill_4_429 r0 *1 0,0
Xsky130_fd_sc_hd__fill_4_429 VSS VDD VDD sky130_fd_sc_hd__fill_4
* cell instance sky130_fd_sc_hd__fill_4_430 r0 *1 0,0
Xsky130_fd_sc_hd__fill_4_430 VSS VDD VDD sky130_fd_sc_hd__fill_4
* cell instance sky130_fd_sc_hd__fill_4_431 r0 *1 0,0
Xsky130_fd_sc_hd__fill_4_431 VSS VDD VDD sky130_fd_sc_hd__fill_4
* cell instance sky130_fd_sc_hd__fill_4_432 r0 *1 0,0
Xsky130_fd_sc_hd__fill_4_432 VSS VDD VDD sky130_fd_sc_hd__fill_4
* cell instance sky130_fd_sc_hd__fill_4_433 r0 *1 0,0
Xsky130_fd_sc_hd__fill_4_433 VSS VDD VDD sky130_fd_sc_hd__fill_4
* cell instance sky130_fd_sc_hd__fill_4_434 r0 *1 0,0
Xsky130_fd_sc_hd__fill_4_434 VSS VDD VDD sky130_fd_sc_hd__fill_4
* cell instance sky130_fd_sc_hd__fill_4_435 r0 *1 0,0
Xsky130_fd_sc_hd__fill_4_435 VSS VDD VDD sky130_fd_sc_hd__fill_4
* cell instance sky130_fd_sc_hd__fill_4_436 r0 *1 0,0
Xsky130_fd_sc_hd__fill_4_436 VSS VDD VDD sky130_fd_sc_hd__fill_4
* cell instance sky130_fd_sc_hd__fill_4_437 r0 *1 0,0
Xsky130_fd_sc_hd__fill_4_437 VSS VDD VDD sky130_fd_sc_hd__fill_4
* cell instance sky130_fd_sc_hd__fill_4_438 r0 *1 0,0
Xsky130_fd_sc_hd__fill_4_438 VSS VDD VDD sky130_fd_sc_hd__fill_4
* cell instance sky130_fd_sc_hd__fill_4_439 r0 *1 0,0
Xsky130_fd_sc_hd__fill_4_439 VSS VDD VDD sky130_fd_sc_hd__fill_4
* cell instance sky130_fd_sc_hd__fill_4_440 r0 *1 0,0
Xsky130_fd_sc_hd__fill_4_440 VSS VDD VDD sky130_fd_sc_hd__fill_4
* cell instance sky130_fd_sc_hd__fill_4_441 r0 *1 0,0
Xsky130_fd_sc_hd__fill_4_441 VSS VDD VDD sky130_fd_sc_hd__fill_4
* cell instance sky130_fd_sc_hd__fill_4_442 r0 *1 0,0
Xsky130_fd_sc_hd__fill_4_442 VSS VDD VDD sky130_fd_sc_hd__fill_4
* cell instance sky130_fd_sc_hd__fill_4_443 r0 *1 0,0
Xsky130_fd_sc_hd__fill_4_443 VSS VDD VDD sky130_fd_sc_hd__fill_4
* cell instance sky130_fd_sc_hd__fill_4_444 r0 *1 0,0
Xsky130_fd_sc_hd__fill_4_444 VSS VDD VDD sky130_fd_sc_hd__fill_4
* cell instance sky130_fd_sc_hd__fill_4_445 r0 *1 0,0
Xsky130_fd_sc_hd__fill_4_445 VSS VDD VDD sky130_fd_sc_hd__fill_4
* cell instance sky130_fd_sc_hd__fill_4_446 r0 *1 0,0
Xsky130_fd_sc_hd__fill_4_446 VSS VDD VDD sky130_fd_sc_hd__fill_4
* cell instance sky130_fd_sc_hd__fill_4_447 r0 *1 0,0
Xsky130_fd_sc_hd__fill_4_447 VSS VDD VDD sky130_fd_sc_hd__fill_4
* cell instance sky130_fd_sc_hd__fill_4_448 r0 *1 0,0
Xsky130_fd_sc_hd__fill_4_448 VSS VDD VDD sky130_fd_sc_hd__fill_4
* cell instance sky130_fd_sc_hd__fill_4_449 r0 *1 0,0
Xsky130_fd_sc_hd__fill_4_449 VSS VDD VDD sky130_fd_sc_hd__fill_4
* cell instance sky130_fd_sc_hd__fill_4_450 r0 *1 0,0
Xsky130_fd_sc_hd__fill_4_450 VSS VDD VDD sky130_fd_sc_hd__fill_4
* cell instance sky130_fd_sc_hd__fill_4_451 r0 *1 0,0
Xsky130_fd_sc_hd__fill_4_451 VSS VDD VDD sky130_fd_sc_hd__fill_4
* cell instance sky130_fd_sc_hd__fill_4_452 r0 *1 0,0
Xsky130_fd_sc_hd__fill_4_452 VSS VDD VDD sky130_fd_sc_hd__fill_4
* cell instance sky130_fd_sc_hd__fill_4_453 r0 *1 0,0
Xsky130_fd_sc_hd__fill_4_453 VSS VDD VDD sky130_fd_sc_hd__fill_4
* cell instance sky130_fd_sc_hd__fill_4_454 r0 *1 0,0
Xsky130_fd_sc_hd__fill_4_454 VSS VDD VDD sky130_fd_sc_hd__fill_4
* cell instance sky130_fd_sc_hd__fill_4_455 r0 *1 0,0
Xsky130_fd_sc_hd__fill_4_455 VSS VDD VDD sky130_fd_sc_hd__fill_4
* cell instance sky130_fd_sc_hd__fill_4_456 r0 *1 0,0
Xsky130_fd_sc_hd__fill_4_456 VSS VDD VDD sky130_fd_sc_hd__fill_4
* cell instance sky130_fd_sc_hd__fill_4_457 r0 *1 0,0
Xsky130_fd_sc_hd__fill_4_457 VSS VDD VDD sky130_fd_sc_hd__fill_4
* cell instance sky130_fd_sc_hd__fill_4_458 r0 *1 0,0
Xsky130_fd_sc_hd__fill_4_458 VSS VDD VDD sky130_fd_sc_hd__fill_4
* cell instance sky130_fd_sc_hd__fill_4_459 r0 *1 0,0
Xsky130_fd_sc_hd__fill_4_459 VSS VDD VDD sky130_fd_sc_hd__fill_4
* cell instance sky130_fd_sc_hd__fill_4_460 r0 *1 0,0
Xsky130_fd_sc_hd__fill_4_460 VSS VDD VDD sky130_fd_sc_hd__fill_4
* cell instance sky130_fd_sc_hd__fill_4_461 r0 *1 0,0
Xsky130_fd_sc_hd__fill_4_461 VSS VDD VDD sky130_fd_sc_hd__fill_4
* cell instance sky130_fd_sc_hd__fill_4_462 r0 *1 0,0
Xsky130_fd_sc_hd__fill_4_462 VSS VDD VDD sky130_fd_sc_hd__fill_4
* cell instance sky130_fd_sc_hd__fill_4_463 r0 *1 0,0
Xsky130_fd_sc_hd__fill_4_463 VSS VDD VDD sky130_fd_sc_hd__fill_4
* cell instance sky130_fd_sc_hd__fill_4_464 r0 *1 0,0
Xsky130_fd_sc_hd__fill_4_464 VSS VDD VDD sky130_fd_sc_hd__fill_4
* cell instance sky130_fd_sc_hd__fill_4_465 r0 *1 0,0
Xsky130_fd_sc_hd__fill_4_465 VSS VDD VDD sky130_fd_sc_hd__fill_4
* cell instance sky130_fd_sc_hd__fill_4_466 r0 *1 0,0
Xsky130_fd_sc_hd__fill_4_466 VSS VDD VDD sky130_fd_sc_hd__fill_4
* cell instance sky130_fd_sc_hd__fill_4_467 r0 *1 0,0
Xsky130_fd_sc_hd__fill_4_467 VSS VDD VDD sky130_fd_sc_hd__fill_4
* cell instance sky130_fd_sc_hd__fill_4_468 r0 *1 0,0
Xsky130_fd_sc_hd__fill_4_468 VSS VDD VDD sky130_fd_sc_hd__fill_4
* cell instance sky130_fd_sc_hd__fill_4_469 r0 *1 0,0
Xsky130_fd_sc_hd__fill_4_469 VSS VDD VDD sky130_fd_sc_hd__fill_4
* cell instance sky130_fd_sc_hd__fill_4_470 r0 *1 0,0
Xsky130_fd_sc_hd__fill_4_470 VSS VDD VDD sky130_fd_sc_hd__fill_4
* cell instance sky130_fd_sc_hd__fill_4_471 r0 *1 0,0
Xsky130_fd_sc_hd__fill_4_471 VSS VDD VDD sky130_fd_sc_hd__fill_4
* cell instance sky130_fd_sc_hd__fill_4_472 r0 *1 0,0
Xsky130_fd_sc_hd__fill_4_472 VSS VDD VDD sky130_fd_sc_hd__fill_4
* cell instance sky130_fd_sc_hd__fill_4_473 r0 *1 0,0
Xsky130_fd_sc_hd__fill_4_473 VSS VDD VDD sky130_fd_sc_hd__fill_4
* cell instance sky130_fd_sc_hd__fill_4_474 r0 *1 0,0
Xsky130_fd_sc_hd__fill_4_474 VSS VDD VDD sky130_fd_sc_hd__fill_4
* cell instance sky130_fd_sc_hd__fill_4_475 r0 *1 0,0
Xsky130_fd_sc_hd__fill_4_475 VSS VDD VDD sky130_fd_sc_hd__fill_4
* cell instance sky130_fd_sc_hd__fill_4_476 r0 *1 0,0
Xsky130_fd_sc_hd__fill_4_476 VSS VDD VDD sky130_fd_sc_hd__fill_4
* cell instance sky130_fd_sc_hd__fill_4_477 r0 *1 0,0
Xsky130_fd_sc_hd__fill_4_477 VSS VDD VDD sky130_fd_sc_hd__fill_4
* cell instance sky130_fd_sc_hd__fill_4_478 r0 *1 0,0
Xsky130_fd_sc_hd__fill_4_478 VSS VDD VDD sky130_fd_sc_hd__fill_4
* cell instance sky130_fd_sc_hd__fill_4_479 r0 *1 0,0
Xsky130_fd_sc_hd__fill_4_479 VSS VDD VDD sky130_fd_sc_hd__fill_4
* cell instance sky130_fd_sc_hd__fill_4_480 r0 *1 0,0
Xsky130_fd_sc_hd__fill_4_480 VSS VDD VDD sky130_fd_sc_hd__fill_4
* cell instance sky130_fd_sc_hd__fill_4_481 r0 *1 0,0
Xsky130_fd_sc_hd__fill_4_481 VSS VDD VDD sky130_fd_sc_hd__fill_4
* cell instance sky130_fd_sc_hd__fill_4_482 r0 *1 0,0
Xsky130_fd_sc_hd__fill_4_482 VSS VDD VDD sky130_fd_sc_hd__fill_4
* cell instance sky130_fd_sc_hd__fill_4_483 r0 *1 0,0
Xsky130_fd_sc_hd__fill_4_483 VSS VDD VDD sky130_fd_sc_hd__fill_4
* cell instance sky130_fd_sc_hd__fill_4_484 r0 *1 0,0
Xsky130_fd_sc_hd__fill_4_484 VSS VDD VDD sky130_fd_sc_hd__fill_4
* cell instance sky130_fd_sc_hd__fill_4_485 r0 *1 0,0
Xsky130_fd_sc_hd__fill_4_485 VSS VDD VDD sky130_fd_sc_hd__fill_4
* cell instance sky130_fd_sc_hd__fill_4_486 r0 *1 0,0
Xsky130_fd_sc_hd__fill_4_486 VSS VDD VDD sky130_fd_sc_hd__fill_4
* cell instance sky130_fd_sc_hd__fill_4_487 r0 *1 0,0
Xsky130_fd_sc_hd__fill_4_487 VSS VDD VDD sky130_fd_sc_hd__fill_4
* cell instance sky130_fd_sc_hd__fill_4_488 r0 *1 0,0
Xsky130_fd_sc_hd__fill_4_488 VSS VDD VDD sky130_fd_sc_hd__fill_4
* cell instance sky130_fd_sc_hd__fill_4_489 r0 *1 0,0
Xsky130_fd_sc_hd__fill_4_489 VSS VDD VDD sky130_fd_sc_hd__fill_4
* cell instance sky130_fd_sc_hd__fill_4_490 r0 *1 0,0
Xsky130_fd_sc_hd__fill_4_490 VSS VDD VDD sky130_fd_sc_hd__fill_4
* cell instance sky130_fd_sc_hd__fill_4_491 r0 *1 0,0
Xsky130_fd_sc_hd__fill_4_491 VSS VDD VDD sky130_fd_sc_hd__fill_4
* cell instance sky130_fd_sc_hd__fill_4_492 r0 *1 0,0
Xsky130_fd_sc_hd__fill_4_492 VSS VDD VDD sky130_fd_sc_hd__fill_4
* cell instance sky130_fd_sc_hd__fill_4_493 r0 *1 0,0
Xsky130_fd_sc_hd__fill_4_493 VSS VDD VDD sky130_fd_sc_hd__fill_4
* cell instance sky130_fd_sc_hd__fill_4_494 r0 *1 0,0
Xsky130_fd_sc_hd__fill_4_494 VSS VDD VDD sky130_fd_sc_hd__fill_4
* cell instance sky130_fd_sc_hd__fill_4_495 r0 *1 0,0
Xsky130_fd_sc_hd__fill_4_495 VSS VDD VDD sky130_fd_sc_hd__fill_4
* cell instance sky130_fd_sc_hd__fill_4_496 r0 *1 0,0
Xsky130_fd_sc_hd__fill_4_496 VSS VDD VDD sky130_fd_sc_hd__fill_4
* cell instance sky130_fd_sc_hd__fill_4_497 r0 *1 0,0
Xsky130_fd_sc_hd__fill_4_497 VSS VDD VDD sky130_fd_sc_hd__fill_4
* cell instance sky130_fd_sc_hd__fill_4_498 r0 *1 0,0
Xsky130_fd_sc_hd__fill_4_498 VSS VDD VDD sky130_fd_sc_hd__fill_4
* cell instance sky130_fd_sc_hd__fill_4_499 r0 *1 0,0
Xsky130_fd_sc_hd__fill_4_499 VSS VDD VDD sky130_fd_sc_hd__fill_4
* cell instance sky130_fd_sc_hd__fill_4_500 r0 *1 0,0
Xsky130_fd_sc_hd__fill_4_500 VSS VDD VDD sky130_fd_sc_hd__fill_4
* cell instance sky130_fd_sc_hd__fill_4_501 r0 *1 0,0
Xsky130_fd_sc_hd__fill_4_501 VSS VDD VDD sky130_fd_sc_hd__fill_4
* cell instance sky130_fd_sc_hd__fill_4_502 r0 *1 0,0
Xsky130_fd_sc_hd__fill_4_502 VSS VDD VDD sky130_fd_sc_hd__fill_4
* cell instance sky130_fd_sc_hd__fill_4_503 r0 *1 0,0
Xsky130_fd_sc_hd__fill_4_503 VSS VDD VDD sky130_fd_sc_hd__fill_4
* cell instance sky130_fd_sc_hd__fill_4_504 r0 *1 0,0
Xsky130_fd_sc_hd__fill_4_504 VSS VDD VDD sky130_fd_sc_hd__fill_4
* cell instance sky130_fd_sc_hd__fill_4_505 r0 *1 0,0
Xsky130_fd_sc_hd__fill_4_505 VSS VDD VDD sky130_fd_sc_hd__fill_4
* cell instance sky130_fd_sc_hd__fill_4_506 r0 *1 0,0
Xsky130_fd_sc_hd__fill_4_506 VSS VDD VDD sky130_fd_sc_hd__fill_4
* cell instance sky130_fd_sc_hd__fill_4_507 r0 *1 0,0
Xsky130_fd_sc_hd__fill_4_507 VSS VDD VDD sky130_fd_sc_hd__fill_4
* cell instance sky130_fd_sc_hd__fill_4_508 r0 *1 0,0
Xsky130_fd_sc_hd__fill_4_508 VSS VDD VDD sky130_fd_sc_hd__fill_4
* cell instance sky130_fd_sc_hd__fill_4_509 r0 *1 0,0
Xsky130_fd_sc_hd__fill_4_509 VSS VDD VDD sky130_fd_sc_hd__fill_4
* cell instance sky130_fd_sc_hd__fill_4_510 r0 *1 0,0
Xsky130_fd_sc_hd__fill_4_510 VSS VDD VDD sky130_fd_sc_hd__fill_4
* cell instance sky130_fd_sc_hd__fill_4_511 r0 *1 0,0
Xsky130_fd_sc_hd__fill_4_511 VSS VDD VDD sky130_fd_sc_hd__fill_4
* cell instance sky130_fd_sc_hd__fill_4_512 r0 *1 0,0
Xsky130_fd_sc_hd__fill_4_512 VSS VDD VDD sky130_fd_sc_hd__fill_4
* cell instance sky130_fd_sc_hd__fill_4_513 r0 *1 0,0
Xsky130_fd_sc_hd__fill_4_513 VSS VDD VDD sky130_fd_sc_hd__fill_4
* cell instance sky130_fd_sc_hd__fill_4_514 r0 *1 0,0
Xsky130_fd_sc_hd__fill_4_514 VSS VDD VDD sky130_fd_sc_hd__fill_4
* cell instance sky130_fd_sc_hd__fill_4_515 r0 *1 0,0
Xsky130_fd_sc_hd__fill_4_515 VSS VDD VDD sky130_fd_sc_hd__fill_4
* cell instance sky130_fd_sc_hd__fill_4_516 r0 *1 0,0
Xsky130_fd_sc_hd__fill_4_516 VSS VDD VDD sky130_fd_sc_hd__fill_4
* cell instance sky130_fd_sc_hd__fill_4_517 r0 *1 0,0
Xsky130_fd_sc_hd__fill_4_517 VSS VDD VDD sky130_fd_sc_hd__fill_4
* cell instance sky130_fd_sc_hd__fill_4_518 r0 *1 0,0
Xsky130_fd_sc_hd__fill_4_518 VSS VDD VDD sky130_fd_sc_hd__fill_4
* cell instance sky130_fd_sc_hd__fill_4_519 r0 *1 0,0
Xsky130_fd_sc_hd__fill_4_519 VSS VDD VDD sky130_fd_sc_hd__fill_4
* cell instance sky130_fd_sc_hd__fill_4_520 r0 *1 0,0
Xsky130_fd_sc_hd__fill_4_520 VSS VDD VDD sky130_fd_sc_hd__fill_4
* cell instance sky130_fd_sc_hd__fill_4_521 r0 *1 0,0
Xsky130_fd_sc_hd__fill_4_521 VSS VDD VDD sky130_fd_sc_hd__fill_4
* cell instance sky130_fd_sc_hd__fill_4_522 r0 *1 0,0
Xsky130_fd_sc_hd__fill_4_522 VSS VDD VDD sky130_fd_sc_hd__fill_4
* cell instance sky130_fd_sc_hd__fill_4_523 r0 *1 0,0
Xsky130_fd_sc_hd__fill_4_523 VSS VDD VDD sky130_fd_sc_hd__fill_4
* cell instance sky130_fd_sc_hd__fill_4_524 r0 *1 0,0
Xsky130_fd_sc_hd__fill_4_524 VSS VDD VDD sky130_fd_sc_hd__fill_4
* cell instance sky130_fd_sc_hd__fill_4_525 r0 *1 0,0
Xsky130_fd_sc_hd__fill_4_525 VSS VDD VDD sky130_fd_sc_hd__fill_4
* cell instance sky130_fd_sc_hd__fill_4_526 r0 *1 0,0
Xsky130_fd_sc_hd__fill_4_526 VSS VDD VDD sky130_fd_sc_hd__fill_4
* cell instance sky130_fd_sc_hd__fill_4_527 r0 *1 0,0
Xsky130_fd_sc_hd__fill_4_527 VSS VDD VDD sky130_fd_sc_hd__fill_4
* cell instance sky130_fd_sc_hd__fill_4_528 r0 *1 0,0
Xsky130_fd_sc_hd__fill_4_528 VSS VDD VDD sky130_fd_sc_hd__fill_4
* cell instance sky130_fd_sc_hd__fill_4_529 r0 *1 0,0
Xsky130_fd_sc_hd__fill_4_529 VSS VDD VDD sky130_fd_sc_hd__fill_4
* cell instance sky130_fd_sc_hd__fill_4_530 r0 *1 0,0
Xsky130_fd_sc_hd__fill_4_530 VSS VDD VDD sky130_fd_sc_hd__fill_4
* cell instance sky130_fd_sc_hd__fill_4_531 r0 *1 0,0
Xsky130_fd_sc_hd__fill_4_531 VSS VDD VDD sky130_fd_sc_hd__fill_4
* cell instance sky130_fd_sc_hd__fill_4_532 r0 *1 0,0
Xsky130_fd_sc_hd__fill_4_532 VSS VDD VDD sky130_fd_sc_hd__fill_4
* cell instance sky130_fd_sc_hd__fill_4_533 r0 *1 0,0
Xsky130_fd_sc_hd__fill_4_533 VSS VDD VDD sky130_fd_sc_hd__fill_4
* cell instance sky130_fd_sc_hd__fill_4_534 r0 *1 0,0
Xsky130_fd_sc_hd__fill_4_534 VSS VDD VDD sky130_fd_sc_hd__fill_4
* cell instance sky130_fd_sc_hd__fill_4_535 r0 *1 0,0
Xsky130_fd_sc_hd__fill_4_535 VSS VDD VDD sky130_fd_sc_hd__fill_4
* cell instance sky130_fd_sc_hd__fill_4_536 r0 *1 0,0
Xsky130_fd_sc_hd__fill_4_536 VSS VDD VDD sky130_fd_sc_hd__fill_4
* cell instance sky130_fd_sc_hd__fill_4_537 r0 *1 0,0
Xsky130_fd_sc_hd__fill_4_537 VSS VDD VDD sky130_fd_sc_hd__fill_4
* cell instance sky130_fd_sc_hd__fill_4_538 r0 *1 0,0
Xsky130_fd_sc_hd__fill_4_538 VSS VDD VDD sky130_fd_sc_hd__fill_4
* cell instance sky130_fd_sc_hd__fill_4_539 r0 *1 0,0
Xsky130_fd_sc_hd__fill_4_539 VSS VDD VDD sky130_fd_sc_hd__fill_4
* cell instance sky130_fd_sc_hd__fill_4_540 r0 *1 0,0
Xsky130_fd_sc_hd__fill_4_540 VSS VDD VDD sky130_fd_sc_hd__fill_4
* cell instance sky130_fd_sc_hd__fill_4_541 r0 *1 0,0
Xsky130_fd_sc_hd__fill_4_541 VSS VDD VDD sky130_fd_sc_hd__fill_4
* cell instance sky130_fd_sc_hd__fill_4_542 r0 *1 0,0
Xsky130_fd_sc_hd__fill_4_542 VSS VDD VDD sky130_fd_sc_hd__fill_4
* cell instance sky130_fd_sc_hd__fill_4_543 r0 *1 0,0
Xsky130_fd_sc_hd__fill_4_543 VSS VDD VDD sky130_fd_sc_hd__fill_4
* cell instance sky130_fd_sc_hd__fill_4_544 r0 *1 0,0
Xsky130_fd_sc_hd__fill_4_544 VSS VDD VDD sky130_fd_sc_hd__fill_4
* cell instance sky130_fd_sc_hd__fill_4_545 r0 *1 0,0
Xsky130_fd_sc_hd__fill_4_545 VSS VDD VDD sky130_fd_sc_hd__fill_4
* cell instance sky130_fd_sc_hd__fill_4_546 r0 *1 0,0
Xsky130_fd_sc_hd__fill_4_546 VSS VDD VDD sky130_fd_sc_hd__fill_4
* cell instance sky130_fd_sc_hd__fill_4_547 r0 *1 0,0
Xsky130_fd_sc_hd__fill_4_547 VSS VDD VDD sky130_fd_sc_hd__fill_4
* cell instance sky130_fd_sc_hd__fill_4_548 r0 *1 0,0
Xsky130_fd_sc_hd__fill_4_548 VSS VDD VDD sky130_fd_sc_hd__fill_4
* cell instance sky130_fd_sc_hd__fill_4_549 r0 *1 0,0
Xsky130_fd_sc_hd__fill_4_549 VSS VDD VDD sky130_fd_sc_hd__fill_4
* cell instance sky130_fd_sc_hd__fill_4_550 r0 *1 0,0
Xsky130_fd_sc_hd__fill_4_550 VSS VDD VDD sky130_fd_sc_hd__fill_4
* cell instance sky130_fd_sc_hd__fill_4_551 r0 *1 0,0
Xsky130_fd_sc_hd__fill_4_551 VSS VDD VDD sky130_fd_sc_hd__fill_4
* cell instance sky130_fd_sc_hd__fill_4_552 r0 *1 0,0
Xsky130_fd_sc_hd__fill_4_552 VSS VDD VDD sky130_fd_sc_hd__fill_4
* cell instance sky130_fd_sc_hd__fill_4_553 r0 *1 0,0
Xsky130_fd_sc_hd__fill_4_553 VSS VDD VDD sky130_fd_sc_hd__fill_4
* cell instance sky130_fd_sc_hd__fill_4_554 r0 *1 0,0
Xsky130_fd_sc_hd__fill_4_554 VSS VDD VDD sky130_fd_sc_hd__fill_4
* cell instance sky130_fd_sc_hd__fill_4_555 r0 *1 0,0
Xsky130_fd_sc_hd__fill_4_555 VSS VDD VDD sky130_fd_sc_hd__fill_4
* cell instance sky130_fd_sc_hd__fill_4_556 r0 *1 0,0
Xsky130_fd_sc_hd__fill_4_556 VSS VDD VDD sky130_fd_sc_hd__fill_4
* cell instance sky130_fd_sc_hd__fill_4_557 r0 *1 0,0
Xsky130_fd_sc_hd__fill_4_557 VSS VDD VDD sky130_fd_sc_hd__fill_4
* cell instance sky130_fd_sc_hd__fill_4_558 r0 *1 0,0
Xsky130_fd_sc_hd__fill_4_558 VSS VDD VDD sky130_fd_sc_hd__fill_4
* cell instance sky130_fd_sc_hd__fill_4_559 r0 *1 0,0
Xsky130_fd_sc_hd__fill_4_559 VSS VDD VDD sky130_fd_sc_hd__fill_4
* cell instance sky130_fd_sc_hd__fill_4_560 r0 *1 0,0
Xsky130_fd_sc_hd__fill_4_560 VSS VDD VDD sky130_fd_sc_hd__fill_4
* cell instance sky130_fd_sc_hd__fill_4_561 r0 *1 0,0
Xsky130_fd_sc_hd__fill_4_561 VSS VDD VDD sky130_fd_sc_hd__fill_4
* cell instance sky130_fd_sc_hd__fill_4_562 r0 *1 0,0
Xsky130_fd_sc_hd__fill_4_562 VSS VDD VDD sky130_fd_sc_hd__fill_4
* cell instance sky130_fd_sc_hd__fill_4_563 r0 *1 0,0
Xsky130_fd_sc_hd__fill_4_563 VSS VDD VDD sky130_fd_sc_hd__fill_4
* cell instance sky130_fd_sc_hd__fill_4_564 r0 *1 0,0
Xsky130_fd_sc_hd__fill_4_564 VSS VDD VDD sky130_fd_sc_hd__fill_4
* cell instance sky130_fd_sc_hd__fill_4_565 r0 *1 0,0
Xsky130_fd_sc_hd__fill_4_565 VSS VDD VDD sky130_fd_sc_hd__fill_4
* cell instance sky130_fd_sc_hd__fill_4_566 r0 *1 0,0
Xsky130_fd_sc_hd__fill_4_566 VSS VDD VDD sky130_fd_sc_hd__fill_4
* cell instance sky130_fd_sc_hd__fill_4_567 r0 *1 0,0
Xsky130_fd_sc_hd__fill_4_567 VSS VDD VDD sky130_fd_sc_hd__fill_4
* cell instance sky130_fd_sc_hd__fill_4_568 r0 *1 0,0
Xsky130_fd_sc_hd__fill_4_568 VSS VDD VDD sky130_fd_sc_hd__fill_4
* cell instance sky130_fd_sc_hd__fill_4_569 r0 *1 0,0
Xsky130_fd_sc_hd__fill_4_569 VSS VDD VDD sky130_fd_sc_hd__fill_4
* cell instance sky130_fd_sc_hd__fill_4_570 r0 *1 0,0
Xsky130_fd_sc_hd__fill_4_570 VSS VDD VDD sky130_fd_sc_hd__fill_4
* cell instance sky130_fd_sc_hd__fill_4_571 r0 *1 0,0
Xsky130_fd_sc_hd__fill_4_571 VSS VDD VDD sky130_fd_sc_hd__fill_4
* cell instance sky130_fd_sc_hd__fill_4_572 r0 *1 0,0
Xsky130_fd_sc_hd__fill_4_572 VSS VDD VDD sky130_fd_sc_hd__fill_4
* cell instance sky130_fd_sc_hd__fill_4_573 r0 *1 0,0
Xsky130_fd_sc_hd__fill_4_573 VSS VDD VDD sky130_fd_sc_hd__fill_4
* cell instance sky130_fd_sc_hd__fill_4_574 r0 *1 0,0
Xsky130_fd_sc_hd__fill_4_574 VSS VDD VDD sky130_fd_sc_hd__fill_4
* cell instance sky130_fd_sc_hd__fill_4_575 r0 *1 0,0
Xsky130_fd_sc_hd__fill_4_575 VSS VDD VDD sky130_fd_sc_hd__fill_4
* cell instance sky130_fd_sc_hd__fill_4_576 r0 *1 0,0
Xsky130_fd_sc_hd__fill_4_576 VSS VDD VDD sky130_fd_sc_hd__fill_4
* cell instance sky130_fd_sc_hd__fill_4_577 r0 *1 0,0
Xsky130_fd_sc_hd__fill_4_577 VSS VDD VDD sky130_fd_sc_hd__fill_4
* cell instance sky130_fd_sc_hd__fill_4_578 r0 *1 0,0
Xsky130_fd_sc_hd__fill_4_578 VSS VDD VDD sky130_fd_sc_hd__fill_4
* cell instance sky130_fd_sc_hd__fill_4_579 r0 *1 0,0
Xsky130_fd_sc_hd__fill_4_579 VSS VDD VDD sky130_fd_sc_hd__fill_4
* cell instance sky130_fd_sc_hd__fill_4_580 r0 *1 0,0
Xsky130_fd_sc_hd__fill_4_580 VSS VDD VDD sky130_fd_sc_hd__fill_4
* cell instance sky130_fd_sc_hd__fill_4_581 r0 *1 0,0
Xsky130_fd_sc_hd__fill_4_581 VSS VDD VDD sky130_fd_sc_hd__fill_4
* cell instance sky130_fd_sc_hd__fill_4_582 r0 *1 0,0
Xsky130_fd_sc_hd__fill_4_582 VSS VDD VDD sky130_fd_sc_hd__fill_4
* cell instance sky130_fd_sc_hd__fill_4_583 r0 *1 0,0
Xsky130_fd_sc_hd__fill_4_583 VSS VDD VDD sky130_fd_sc_hd__fill_4
* cell instance sky130_fd_sc_hd__fill_8_0 r0 *1 0,0
Xsky130_fd_sc_hd__fill_8_0 VSS VDD VDD sky130_fd_sc_hd__fill_8
* cell instance sky130_fd_sc_hd__fill_8_1 r0 *1 0,0
Xsky130_fd_sc_hd__fill_8_1 VSS VDD VDD sky130_fd_sc_hd__fill_8
* cell instance sky130_fd_sc_hd__fill_8_2 r0 *1 0,0
Xsky130_fd_sc_hd__fill_8_2 VSS VDD VDD sky130_fd_sc_hd__fill_8
* cell instance sky130_fd_sc_hd__fill_8_3 r0 *1 0,0
Xsky130_fd_sc_hd__fill_8_3 VSS VDD VDD sky130_fd_sc_hd__fill_8
* cell instance sky130_fd_sc_hd__fill_8_4 r0 *1 0,0
Xsky130_fd_sc_hd__fill_8_4 VSS VDD VDD sky130_fd_sc_hd__fill_8
* cell instance sky130_fd_sc_hd__fill_8_5 r0 *1 0,0
Xsky130_fd_sc_hd__fill_8_5 VSS VDD VDD sky130_fd_sc_hd__fill_8
* cell instance sky130_fd_sc_hd__fill_8_6 r0 *1 0,0
Xsky130_fd_sc_hd__fill_8_6 VSS VDD VDD sky130_fd_sc_hd__fill_8
* cell instance sky130_fd_sc_hd__fill_8_7 r0 *1 0,0
Xsky130_fd_sc_hd__fill_8_7 VSS VDD VDD sky130_fd_sc_hd__fill_8
* cell instance sky130_fd_sc_hd__fill_8_8 r0 *1 0,0
Xsky130_fd_sc_hd__fill_8_8 VSS VDD VDD sky130_fd_sc_hd__fill_8
* cell instance sky130_fd_sc_hd__fill_8_9 r0 *1 0,0
Xsky130_fd_sc_hd__fill_8_9 VSS VDD VDD sky130_fd_sc_hd__fill_8
* cell instance sky130_fd_sc_hd__fill_8_10 r0 *1 0,0
Xsky130_fd_sc_hd__fill_8_10 VSS VDD VDD sky130_fd_sc_hd__fill_8
* cell instance sky130_fd_sc_hd__fill_8_11 r0 *1 0,0
Xsky130_fd_sc_hd__fill_8_11 VSS VDD VDD sky130_fd_sc_hd__fill_8
* cell instance sky130_fd_sc_hd__fill_8_12 r0 *1 0,0
Xsky130_fd_sc_hd__fill_8_12 VSS VDD VDD sky130_fd_sc_hd__fill_8
* cell instance sky130_fd_sc_hd__fill_8_13 r0 *1 0,0
Xsky130_fd_sc_hd__fill_8_13 VSS VDD VDD sky130_fd_sc_hd__fill_8
* cell instance sky130_fd_sc_hd__fill_8_14 r0 *1 0,0
Xsky130_fd_sc_hd__fill_8_14 VSS VDD VDD sky130_fd_sc_hd__fill_8
* cell instance sky130_fd_sc_hd__fill_8_15 r0 *1 0,0
Xsky130_fd_sc_hd__fill_8_15 VSS VDD VDD sky130_fd_sc_hd__fill_8
* cell instance sky130_fd_sc_hd__fill_8_16 r0 *1 0,0
Xsky130_fd_sc_hd__fill_8_16 VSS VDD VDD sky130_fd_sc_hd__fill_8
* cell instance sky130_fd_sc_hd__fill_8_17 r0 *1 0,0
Xsky130_fd_sc_hd__fill_8_17 VSS VDD VDD sky130_fd_sc_hd__fill_8
* cell instance sky130_fd_sc_hd__fill_8_18 r0 *1 0,0
Xsky130_fd_sc_hd__fill_8_18 VSS VDD VDD sky130_fd_sc_hd__fill_8
* cell instance sky130_fd_sc_hd__fill_8_19 r0 *1 0,0
Xsky130_fd_sc_hd__fill_8_19 VSS VDD VDD sky130_fd_sc_hd__fill_8
* cell instance sky130_fd_sc_hd__fill_8_20 r0 *1 0,0
Xsky130_fd_sc_hd__fill_8_20 VSS VDD VDD sky130_fd_sc_hd__fill_8
* cell instance sky130_fd_sc_hd__fill_8_21 r0 *1 0,0
Xsky130_fd_sc_hd__fill_8_21 VSS VDD VDD sky130_fd_sc_hd__fill_8
* cell instance sky130_fd_sc_hd__fill_8_22 r0 *1 0,0
Xsky130_fd_sc_hd__fill_8_22 VSS VDD VDD sky130_fd_sc_hd__fill_8
* cell instance sky130_fd_sc_hd__fill_8_23 r0 *1 0,0
Xsky130_fd_sc_hd__fill_8_23 VSS VDD VDD sky130_fd_sc_hd__fill_8
* cell instance sky130_fd_sc_hd__fill_8_24 r0 *1 0,0
Xsky130_fd_sc_hd__fill_8_24 VSS VDD VDD sky130_fd_sc_hd__fill_8
* cell instance sky130_fd_sc_hd__fill_8_25 r0 *1 0,0
Xsky130_fd_sc_hd__fill_8_25 VSS VDD VDD sky130_fd_sc_hd__fill_8
* cell instance sky130_fd_sc_hd__fill_8_26 r0 *1 0,0
Xsky130_fd_sc_hd__fill_8_26 VSS VDD VDD sky130_fd_sc_hd__fill_8
* cell instance sky130_fd_sc_hd__fill_8_27 r0 *1 0,0
Xsky130_fd_sc_hd__fill_8_27 VSS VDD VDD sky130_fd_sc_hd__fill_8
* cell instance sky130_fd_sc_hd__fill_8_28 r0 *1 0,0
Xsky130_fd_sc_hd__fill_8_28 VSS VDD VDD sky130_fd_sc_hd__fill_8
* cell instance sky130_fd_sc_hd__fill_8_29 r0 *1 0,0
Xsky130_fd_sc_hd__fill_8_29 VSS VDD VDD sky130_fd_sc_hd__fill_8
* cell instance sky130_fd_sc_hd__fill_8_30 r0 *1 0,0
Xsky130_fd_sc_hd__fill_8_30 VSS VDD VDD sky130_fd_sc_hd__fill_8
* cell instance sky130_fd_sc_hd__fill_8_31 r0 *1 0,0
Xsky130_fd_sc_hd__fill_8_31 VSS VDD VDD sky130_fd_sc_hd__fill_8
* cell instance sky130_fd_sc_hd__fill_8_32 r0 *1 0,0
Xsky130_fd_sc_hd__fill_8_32 VSS VDD VDD sky130_fd_sc_hd__fill_8
* cell instance sky130_fd_sc_hd__fill_8_33 r0 *1 0,0
Xsky130_fd_sc_hd__fill_8_33 VSS VDD VDD sky130_fd_sc_hd__fill_8
* cell instance sky130_fd_sc_hd__fill_8_34 r0 *1 0,0
Xsky130_fd_sc_hd__fill_8_34 VSS VDD VDD sky130_fd_sc_hd__fill_8
* cell instance sky130_fd_sc_hd__fill_8_35 r0 *1 0,0
Xsky130_fd_sc_hd__fill_8_35 VSS VDD VDD sky130_fd_sc_hd__fill_8
* cell instance sky130_fd_sc_hd__fill_8_36 r0 *1 0,0
Xsky130_fd_sc_hd__fill_8_36 VSS VDD VDD sky130_fd_sc_hd__fill_8
* cell instance sky130_fd_sc_hd__fill_8_37 r0 *1 0,0
Xsky130_fd_sc_hd__fill_8_37 VSS VDD VDD sky130_fd_sc_hd__fill_8
* cell instance sky130_fd_sc_hd__fill_8_38 r0 *1 0,0
Xsky130_fd_sc_hd__fill_8_38 VSS VDD VDD sky130_fd_sc_hd__fill_8
* cell instance sky130_fd_sc_hd__fill_8_39 r0 *1 0,0
Xsky130_fd_sc_hd__fill_8_39 VSS VDD VDD sky130_fd_sc_hd__fill_8
* cell instance sky130_fd_sc_hd__fill_8_40 r0 *1 0,0
Xsky130_fd_sc_hd__fill_8_40 VSS VDD VDD sky130_fd_sc_hd__fill_8
* cell instance sky130_fd_sc_hd__fill_8_41 r0 *1 0,0
Xsky130_fd_sc_hd__fill_8_41 VSS VDD VDD sky130_fd_sc_hd__fill_8
* cell instance sky130_fd_sc_hd__fill_8_42 r0 *1 0,0
Xsky130_fd_sc_hd__fill_8_42 VSS VDD VDD sky130_fd_sc_hd__fill_8
* cell instance sky130_fd_sc_hd__fill_8_43 r0 *1 0,0
Xsky130_fd_sc_hd__fill_8_43 VSS VDD VDD sky130_fd_sc_hd__fill_8
* cell instance sky130_fd_sc_hd__fill_8_44 r0 *1 0,0
Xsky130_fd_sc_hd__fill_8_44 VSS VDD VDD sky130_fd_sc_hd__fill_8
* cell instance sky130_fd_sc_hd__fill_8_45 r0 *1 0,0
Xsky130_fd_sc_hd__fill_8_45 VSS VDD VDD sky130_fd_sc_hd__fill_8
* cell instance sky130_fd_sc_hd__fill_8_46 r0 *1 0,0
Xsky130_fd_sc_hd__fill_8_46 VSS VDD VDD sky130_fd_sc_hd__fill_8
* cell instance sky130_fd_sc_hd__fill_8_47 r0 *1 0,0
Xsky130_fd_sc_hd__fill_8_47 VSS VDD VDD sky130_fd_sc_hd__fill_8
* cell instance sky130_fd_sc_hd__fill_8_48 r0 *1 0,0
Xsky130_fd_sc_hd__fill_8_48 VSS VDD VDD sky130_fd_sc_hd__fill_8
* cell instance sky130_fd_sc_hd__fill_8_49 r0 *1 0,0
Xsky130_fd_sc_hd__fill_8_49 VSS VDD VDD sky130_fd_sc_hd__fill_8
* cell instance sky130_fd_sc_hd__fill_8_50 r0 *1 0,0
Xsky130_fd_sc_hd__fill_8_50 VSS VDD VDD sky130_fd_sc_hd__fill_8
* cell instance sky130_fd_sc_hd__fill_8_51 r0 *1 0,0
Xsky130_fd_sc_hd__fill_8_51 VSS VDD VDD sky130_fd_sc_hd__fill_8
* cell instance sky130_fd_sc_hd__fill_8_52 r0 *1 0,0
Xsky130_fd_sc_hd__fill_8_52 VSS VDD VDD sky130_fd_sc_hd__fill_8
* cell instance sky130_fd_sc_hd__fill_8_53 r0 *1 0,0
Xsky130_fd_sc_hd__fill_8_53 VSS VDD VDD sky130_fd_sc_hd__fill_8
* cell instance sky130_fd_sc_hd__fill_8_54 r0 *1 0,0
Xsky130_fd_sc_hd__fill_8_54 VSS VDD VDD sky130_fd_sc_hd__fill_8
* cell instance sky130_fd_sc_hd__fill_8_55 r0 *1 0,0
Xsky130_fd_sc_hd__fill_8_55 VSS VDD VDD sky130_fd_sc_hd__fill_8
* cell instance sky130_fd_sc_hd__fill_8_56 r0 *1 0,0
Xsky130_fd_sc_hd__fill_8_56 VSS VDD VDD sky130_fd_sc_hd__fill_8
* cell instance sky130_fd_sc_hd__fill_8_57 r0 *1 0,0
Xsky130_fd_sc_hd__fill_8_57 VSS VDD VDD sky130_fd_sc_hd__fill_8
* cell instance sky130_fd_sc_hd__fill_8_58 r0 *1 0,0
Xsky130_fd_sc_hd__fill_8_58 VSS VDD VDD sky130_fd_sc_hd__fill_8
* cell instance sky130_fd_sc_hd__fill_8_59 r0 *1 0,0
Xsky130_fd_sc_hd__fill_8_59 VSS VDD VDD sky130_fd_sc_hd__fill_8
* cell instance sky130_fd_sc_hd__fill_8_60 r0 *1 0,0
Xsky130_fd_sc_hd__fill_8_60 VSS VDD VDD sky130_fd_sc_hd__fill_8
* cell instance sky130_fd_sc_hd__fill_8_61 r0 *1 0,0
Xsky130_fd_sc_hd__fill_8_61 VSS VDD VDD sky130_fd_sc_hd__fill_8
* cell instance sky130_fd_sc_hd__fill_8_62 r0 *1 0,0
Xsky130_fd_sc_hd__fill_8_62 VSS VDD VDD sky130_fd_sc_hd__fill_8
* cell instance sky130_fd_sc_hd__fill_8_63 r0 *1 0,0
Xsky130_fd_sc_hd__fill_8_63 VSS VDD VDD sky130_fd_sc_hd__fill_8
* cell instance sky130_fd_sc_hd__fill_8_64 r0 *1 0,0
Xsky130_fd_sc_hd__fill_8_64 VSS VDD VDD sky130_fd_sc_hd__fill_8
* cell instance sky130_fd_sc_hd__fill_8_65 r0 *1 0,0
Xsky130_fd_sc_hd__fill_8_65 VSS VDD VDD sky130_fd_sc_hd__fill_8
* cell instance sky130_fd_sc_hd__fill_8_66 r0 *1 0,0
Xsky130_fd_sc_hd__fill_8_66 VSS VDD VDD sky130_fd_sc_hd__fill_8
* cell instance sky130_fd_sc_hd__fill_8_67 r0 *1 0,0
Xsky130_fd_sc_hd__fill_8_67 VSS VDD VDD sky130_fd_sc_hd__fill_8
* cell instance sky130_fd_sc_hd__fill_8_68 r0 *1 0,0
Xsky130_fd_sc_hd__fill_8_68 VSS VDD VDD sky130_fd_sc_hd__fill_8
* cell instance sky130_fd_sc_hd__fill_8_69 r0 *1 0,0
Xsky130_fd_sc_hd__fill_8_69 VSS VDD VDD sky130_fd_sc_hd__fill_8
* cell instance sky130_fd_sc_hd__fill_8_70 r0 *1 0,0
Xsky130_fd_sc_hd__fill_8_70 VSS VDD VDD sky130_fd_sc_hd__fill_8
* cell instance sky130_fd_sc_hd__fill_8_71 r0 *1 0,0
Xsky130_fd_sc_hd__fill_8_71 VSS VDD VDD sky130_fd_sc_hd__fill_8
* cell instance sky130_fd_sc_hd__fill_8_72 r0 *1 0,0
Xsky130_fd_sc_hd__fill_8_72 VSS VDD VDD sky130_fd_sc_hd__fill_8
* cell instance sky130_fd_sc_hd__fill_8_73 r0 *1 0,0
Xsky130_fd_sc_hd__fill_8_73 VSS VDD VDD sky130_fd_sc_hd__fill_8
* cell instance sky130_fd_sc_hd__fill_8_74 r0 *1 0,0
Xsky130_fd_sc_hd__fill_8_74 VSS VDD VDD sky130_fd_sc_hd__fill_8
* cell instance sky130_fd_sc_hd__fill_8_75 r0 *1 0,0
Xsky130_fd_sc_hd__fill_8_75 VSS VDD VDD sky130_fd_sc_hd__fill_8
* cell instance sky130_fd_sc_hd__fill_8_76 r0 *1 0,0
Xsky130_fd_sc_hd__fill_8_76 VSS VDD VDD sky130_fd_sc_hd__fill_8
* cell instance sky130_fd_sc_hd__fill_8_77 r0 *1 0,0
Xsky130_fd_sc_hd__fill_8_77 VSS VDD VDD sky130_fd_sc_hd__fill_8
* cell instance sky130_fd_sc_hd__fill_8_78 r0 *1 0,0
Xsky130_fd_sc_hd__fill_8_78 VSS VDD VDD sky130_fd_sc_hd__fill_8
* cell instance sky130_fd_sc_hd__fill_8_79 r0 *1 0,0
Xsky130_fd_sc_hd__fill_8_79 VSS VDD VDD sky130_fd_sc_hd__fill_8
* cell instance sky130_fd_sc_hd__fill_8_80 r0 *1 0,0
Xsky130_fd_sc_hd__fill_8_80 VSS VDD VDD sky130_fd_sc_hd__fill_8
* cell instance sky130_fd_sc_hd__fill_8_81 r0 *1 0,0
Xsky130_fd_sc_hd__fill_8_81 VSS VDD VDD sky130_fd_sc_hd__fill_8
* cell instance sky130_fd_sc_hd__fill_8_82 r0 *1 0,0
Xsky130_fd_sc_hd__fill_8_82 VSS VDD VDD sky130_fd_sc_hd__fill_8
* cell instance sky130_fd_sc_hd__fill_8_83 r0 *1 0,0
Xsky130_fd_sc_hd__fill_8_83 VSS VDD VDD sky130_fd_sc_hd__fill_8
* cell instance sky130_fd_sc_hd__fill_8_84 r0 *1 0,0
Xsky130_fd_sc_hd__fill_8_84 VSS VDD VDD sky130_fd_sc_hd__fill_8
* cell instance sky130_fd_sc_hd__fill_8_85 r0 *1 0,0
Xsky130_fd_sc_hd__fill_8_85 VSS VDD VDD sky130_fd_sc_hd__fill_8
* cell instance sky130_fd_sc_hd__fill_8_86 r0 *1 0,0
Xsky130_fd_sc_hd__fill_8_86 VSS VDD VDD sky130_fd_sc_hd__fill_8
* cell instance sky130_fd_sc_hd__fill_8_87 r0 *1 0,0
Xsky130_fd_sc_hd__fill_8_87 VSS VDD VDD sky130_fd_sc_hd__fill_8
* cell instance sky130_fd_sc_hd__fill_8_88 r0 *1 0,0
Xsky130_fd_sc_hd__fill_8_88 VSS VDD VDD sky130_fd_sc_hd__fill_8
* cell instance sky130_fd_sc_hd__fill_8_89 r0 *1 0,0
Xsky130_fd_sc_hd__fill_8_89 VSS VDD VDD sky130_fd_sc_hd__fill_8
* cell instance sky130_fd_sc_hd__fill_8_90 r0 *1 0,0
Xsky130_fd_sc_hd__fill_8_90 VSS VDD VDD sky130_fd_sc_hd__fill_8
* cell instance sky130_fd_sc_hd__fill_8_91 r0 *1 0,0
Xsky130_fd_sc_hd__fill_8_91 VSS VDD VDD sky130_fd_sc_hd__fill_8
* cell instance sky130_fd_sc_hd__fill_8_92 r0 *1 0,0
Xsky130_fd_sc_hd__fill_8_92 VSS VDD VDD sky130_fd_sc_hd__fill_8
* cell instance sky130_fd_sc_hd__fill_8_93 r0 *1 0,0
Xsky130_fd_sc_hd__fill_8_93 VSS VDD VDD sky130_fd_sc_hd__fill_8
* cell instance sky130_fd_sc_hd__fill_8_94 r0 *1 0,0
Xsky130_fd_sc_hd__fill_8_94 VSS VDD VDD sky130_fd_sc_hd__fill_8
* cell instance sky130_fd_sc_hd__fill_8_95 r0 *1 0,0
Xsky130_fd_sc_hd__fill_8_95 VSS VDD VDD sky130_fd_sc_hd__fill_8
* cell instance sky130_fd_sc_hd__fill_8_96 r0 *1 0,0
Xsky130_fd_sc_hd__fill_8_96 VSS VDD VDD sky130_fd_sc_hd__fill_8
* cell instance sky130_fd_sc_hd__fill_8_97 r0 *1 0,0
Xsky130_fd_sc_hd__fill_8_97 VSS VDD VDD sky130_fd_sc_hd__fill_8
* cell instance sky130_fd_sc_hd__fill_8_98 r0 *1 0,0
Xsky130_fd_sc_hd__fill_8_98 VSS VDD VDD sky130_fd_sc_hd__fill_8
* cell instance sky130_fd_sc_hd__fill_8_99 r0 *1 0,0
Xsky130_fd_sc_hd__fill_8_99 VSS VDD VDD sky130_fd_sc_hd__fill_8
* cell instance sky130_fd_sc_hd__fill_8_100 r0 *1 0,0
Xsky130_fd_sc_hd__fill_8_100 VSS VDD VDD sky130_fd_sc_hd__fill_8
* cell instance sky130_fd_sc_hd__fill_8_101 r0 *1 0,0
Xsky130_fd_sc_hd__fill_8_101 VSS VDD VDD sky130_fd_sc_hd__fill_8
* cell instance sky130_fd_sc_hd__fill_8_102 r0 *1 0,0
Xsky130_fd_sc_hd__fill_8_102 VSS VDD VDD sky130_fd_sc_hd__fill_8
* cell instance sky130_fd_sc_hd__fill_8_103 r0 *1 0,0
Xsky130_fd_sc_hd__fill_8_103 VSS VDD VDD sky130_fd_sc_hd__fill_8
* cell instance sky130_fd_sc_hd__fill_8_104 r0 *1 0,0
Xsky130_fd_sc_hd__fill_8_104 VSS VDD VDD sky130_fd_sc_hd__fill_8
* cell instance sky130_fd_sc_hd__fill_8_105 r0 *1 0,0
Xsky130_fd_sc_hd__fill_8_105 VSS VDD VDD sky130_fd_sc_hd__fill_8
* cell instance sky130_fd_sc_hd__fill_8_106 r0 *1 0,0
Xsky130_fd_sc_hd__fill_8_106 VSS VDD VDD sky130_fd_sc_hd__fill_8
* cell instance sky130_fd_sc_hd__fill_8_107 r0 *1 0,0
Xsky130_fd_sc_hd__fill_8_107 VSS VDD VDD sky130_fd_sc_hd__fill_8
* cell instance sky130_fd_sc_hd__fill_8_108 r0 *1 0,0
Xsky130_fd_sc_hd__fill_8_108 VSS VDD VDD sky130_fd_sc_hd__fill_8
* cell instance sky130_fd_sc_hd__fill_8_109 r0 *1 0,0
Xsky130_fd_sc_hd__fill_8_109 VSS VDD VDD sky130_fd_sc_hd__fill_8
* cell instance sky130_fd_sc_hd__fill_8_110 r0 *1 0,0
Xsky130_fd_sc_hd__fill_8_110 VSS VDD VDD sky130_fd_sc_hd__fill_8
* cell instance sky130_fd_sc_hd__fill_8_111 r0 *1 0,0
Xsky130_fd_sc_hd__fill_8_111 VSS VDD VDD sky130_fd_sc_hd__fill_8
* cell instance sky130_fd_sc_hd__fill_8_112 r0 *1 0,0
Xsky130_fd_sc_hd__fill_8_112 VSS VDD VDD sky130_fd_sc_hd__fill_8
* cell instance sky130_fd_sc_hd__fill_8_113 r0 *1 0,0
Xsky130_fd_sc_hd__fill_8_113 VSS VDD VDD sky130_fd_sc_hd__fill_8
* cell instance sky130_fd_sc_hd__fill_8_114 r0 *1 0,0
Xsky130_fd_sc_hd__fill_8_114 VSS VDD VDD sky130_fd_sc_hd__fill_8
* cell instance sky130_fd_sc_hd__fill_8_115 r0 *1 0,0
Xsky130_fd_sc_hd__fill_8_115 VSS VDD VDD sky130_fd_sc_hd__fill_8
* cell instance sky130_fd_sc_hd__fill_8_116 r0 *1 0,0
Xsky130_fd_sc_hd__fill_8_116 VSS VDD VDD sky130_fd_sc_hd__fill_8
* cell instance sky130_fd_sc_hd__fill_8_117 r0 *1 0,0
Xsky130_fd_sc_hd__fill_8_117 VSS VDD VDD sky130_fd_sc_hd__fill_8
* cell instance sky130_fd_sc_hd__fill_8_118 r0 *1 0,0
Xsky130_fd_sc_hd__fill_8_118 VSS VDD VDD sky130_fd_sc_hd__fill_8
* cell instance sky130_fd_sc_hd__fill_8_119 r0 *1 0,0
Xsky130_fd_sc_hd__fill_8_119 VSS VDD VDD sky130_fd_sc_hd__fill_8
* cell instance sky130_fd_sc_hd__fill_8_120 r0 *1 0,0
Xsky130_fd_sc_hd__fill_8_120 VSS VDD VDD sky130_fd_sc_hd__fill_8
* cell instance sky130_fd_sc_hd__fill_8_121 r0 *1 0,0
Xsky130_fd_sc_hd__fill_8_121 VSS VDD VDD sky130_fd_sc_hd__fill_8
* cell instance sky130_fd_sc_hd__fill_8_122 r0 *1 0,0
Xsky130_fd_sc_hd__fill_8_122 VSS VDD VDD sky130_fd_sc_hd__fill_8
* cell instance sky130_fd_sc_hd__fill_8_123 r0 *1 0,0
Xsky130_fd_sc_hd__fill_8_123 VSS VDD VDD sky130_fd_sc_hd__fill_8
* cell instance sky130_fd_sc_hd__fill_8_124 r0 *1 0,0
Xsky130_fd_sc_hd__fill_8_124 VSS VDD VDD sky130_fd_sc_hd__fill_8
* cell instance sky130_fd_sc_hd__fill_8_125 r0 *1 0,0
Xsky130_fd_sc_hd__fill_8_125 VSS VDD VDD sky130_fd_sc_hd__fill_8
* cell instance sky130_fd_sc_hd__fill_8_126 r0 *1 0,0
Xsky130_fd_sc_hd__fill_8_126 VSS VDD VDD sky130_fd_sc_hd__fill_8
* cell instance sky130_fd_sc_hd__fill_8_127 r0 *1 0,0
Xsky130_fd_sc_hd__fill_8_127 VSS VDD VDD sky130_fd_sc_hd__fill_8
* cell instance sky130_fd_sc_hd__fill_8_128 r0 *1 0,0
Xsky130_fd_sc_hd__fill_8_128 VSS VDD VDD sky130_fd_sc_hd__fill_8
* cell instance sky130_fd_sc_hd__fill_8_129 r0 *1 0,0
Xsky130_fd_sc_hd__fill_8_129 VSS VDD VDD sky130_fd_sc_hd__fill_8
* cell instance sky130_fd_sc_hd__fill_8_130 r0 *1 0,0
Xsky130_fd_sc_hd__fill_8_130 VSS VDD VDD sky130_fd_sc_hd__fill_8
* cell instance sky130_fd_sc_hd__fill_8_131 r0 *1 0,0
Xsky130_fd_sc_hd__fill_8_131 VSS VDD VDD sky130_fd_sc_hd__fill_8
* cell instance sky130_fd_sc_hd__fill_8_132 r0 *1 0,0
Xsky130_fd_sc_hd__fill_8_132 VSS VDD VDD sky130_fd_sc_hd__fill_8
* cell instance sky130_fd_sc_hd__fill_8_133 r0 *1 0,0
Xsky130_fd_sc_hd__fill_8_133 VSS VDD VDD sky130_fd_sc_hd__fill_8
* cell instance sky130_fd_sc_hd__fill_8_134 r0 *1 0,0
Xsky130_fd_sc_hd__fill_8_134 VSS VDD VDD sky130_fd_sc_hd__fill_8
* cell instance sky130_fd_sc_hd__fill_8_135 r0 *1 0,0
Xsky130_fd_sc_hd__fill_8_135 VSS VDD VDD sky130_fd_sc_hd__fill_8
* cell instance sky130_fd_sc_hd__fill_8_136 r0 *1 0,0
Xsky130_fd_sc_hd__fill_8_136 VSS VDD VDD sky130_fd_sc_hd__fill_8
* cell instance sky130_fd_sc_hd__fill_8_137 r0 *1 0,0
Xsky130_fd_sc_hd__fill_8_137 VSS VDD VDD sky130_fd_sc_hd__fill_8
* cell instance sky130_fd_sc_hd__fill_8_138 r0 *1 0,0
Xsky130_fd_sc_hd__fill_8_138 VSS VDD VDD sky130_fd_sc_hd__fill_8
* cell instance sky130_fd_sc_hd__fill_8_139 r0 *1 0,0
Xsky130_fd_sc_hd__fill_8_139 VSS VDD VDD sky130_fd_sc_hd__fill_8
* cell instance sky130_fd_sc_hd__fill_8_140 r0 *1 0,0
Xsky130_fd_sc_hd__fill_8_140 VSS VDD VDD sky130_fd_sc_hd__fill_8
* cell instance sky130_fd_sc_hd__fill_8_141 r0 *1 0,0
Xsky130_fd_sc_hd__fill_8_141 VSS VDD VDD sky130_fd_sc_hd__fill_8
* cell instance sky130_fd_sc_hd__fill_8_142 r0 *1 0,0
Xsky130_fd_sc_hd__fill_8_142 VSS VDD VDD sky130_fd_sc_hd__fill_8
* cell instance sky130_fd_sc_hd__fill_8_143 r0 *1 0,0
Xsky130_fd_sc_hd__fill_8_143 VSS VDD VDD sky130_fd_sc_hd__fill_8
* cell instance sky130_fd_sc_hd__fill_8_144 r0 *1 0,0
Xsky130_fd_sc_hd__fill_8_144 VSS VDD VDD sky130_fd_sc_hd__fill_8
* cell instance sky130_fd_sc_hd__fill_8_145 r0 *1 0,0
Xsky130_fd_sc_hd__fill_8_145 VSS VDD VDD sky130_fd_sc_hd__fill_8
* cell instance sky130_fd_sc_hd__fill_8_146 r0 *1 0,0
Xsky130_fd_sc_hd__fill_8_146 VSS VDD VDD sky130_fd_sc_hd__fill_8
* cell instance sky130_fd_sc_hd__fill_8_147 r0 *1 0,0
Xsky130_fd_sc_hd__fill_8_147 VSS VDD VDD sky130_fd_sc_hd__fill_8
* cell instance sky130_fd_sc_hd__fill_8_148 r0 *1 0,0
Xsky130_fd_sc_hd__fill_8_148 VSS VDD VDD sky130_fd_sc_hd__fill_8
* cell instance sky130_fd_sc_hd__fill_8_149 r0 *1 0,0
Xsky130_fd_sc_hd__fill_8_149 VSS VDD VDD sky130_fd_sc_hd__fill_8
* cell instance sky130_fd_sc_hd__fill_8_150 r0 *1 0,0
Xsky130_fd_sc_hd__fill_8_150 VSS VDD VDD sky130_fd_sc_hd__fill_8
* cell instance sky130_fd_sc_hd__fill_8_151 r0 *1 0,0
Xsky130_fd_sc_hd__fill_8_151 VSS VDD VDD sky130_fd_sc_hd__fill_8
* cell instance sky130_fd_sc_hd__fill_8_152 r0 *1 0,0
Xsky130_fd_sc_hd__fill_8_152 VSS VDD VDD sky130_fd_sc_hd__fill_8
* cell instance sky130_fd_sc_hd__fill_8_153 r0 *1 0,0
Xsky130_fd_sc_hd__fill_8_153 VSS VDD VDD sky130_fd_sc_hd__fill_8
* cell instance sky130_fd_sc_hd__fill_8_154 r0 *1 0,0
Xsky130_fd_sc_hd__fill_8_154 VSS VDD VDD sky130_fd_sc_hd__fill_8
* cell instance sky130_fd_sc_hd__fill_8_155 r0 *1 0,0
Xsky130_fd_sc_hd__fill_8_155 VSS VDD VDD sky130_fd_sc_hd__fill_8
* cell instance sky130_fd_sc_hd__fill_8_156 r0 *1 0,0
Xsky130_fd_sc_hd__fill_8_156 VSS VDD VDD sky130_fd_sc_hd__fill_8
* cell instance sky130_fd_sc_hd__fill_8_157 r0 *1 0,0
Xsky130_fd_sc_hd__fill_8_157 VSS VDD VDD sky130_fd_sc_hd__fill_8
* cell instance sky130_fd_sc_hd__fill_8_158 r0 *1 0,0
Xsky130_fd_sc_hd__fill_8_158 VSS VDD VDD sky130_fd_sc_hd__fill_8
* cell instance sky130_fd_sc_hd__fill_8_159 r0 *1 0,0
Xsky130_fd_sc_hd__fill_8_159 VSS VDD VDD sky130_fd_sc_hd__fill_8
* cell instance sky130_fd_sc_hd__fill_8_160 r0 *1 0,0
Xsky130_fd_sc_hd__fill_8_160 VSS VDD VDD sky130_fd_sc_hd__fill_8
* cell instance sky130_fd_sc_hd__fill_8_161 r0 *1 0,0
Xsky130_fd_sc_hd__fill_8_161 VSS VDD VDD sky130_fd_sc_hd__fill_8
* cell instance sky130_fd_sc_hd__fill_8_162 r0 *1 0,0
Xsky130_fd_sc_hd__fill_8_162 VSS VDD VDD sky130_fd_sc_hd__fill_8
* cell instance sky130_fd_sc_hd__fill_8_163 r0 *1 0,0
Xsky130_fd_sc_hd__fill_8_163 VSS VDD VDD sky130_fd_sc_hd__fill_8
* cell instance sky130_fd_sc_hd__fill_8_164 r0 *1 0,0
Xsky130_fd_sc_hd__fill_8_164 VSS VDD VDD sky130_fd_sc_hd__fill_8
* cell instance sky130_fd_sc_hd__fill_8_165 r0 *1 0,0
Xsky130_fd_sc_hd__fill_8_165 VSS VDD VDD sky130_fd_sc_hd__fill_8
* cell instance sky130_fd_sc_hd__fill_8_166 r0 *1 0,0
Xsky130_fd_sc_hd__fill_8_166 VSS VDD VDD sky130_fd_sc_hd__fill_8
* cell instance sky130_fd_sc_hd__fill_8_167 r0 *1 0,0
Xsky130_fd_sc_hd__fill_8_167 VSS VDD VDD sky130_fd_sc_hd__fill_8
* cell instance sky130_fd_sc_hd__fill_8_168 r0 *1 0,0
Xsky130_fd_sc_hd__fill_8_168 VSS VDD VDD sky130_fd_sc_hd__fill_8
* cell instance sky130_fd_sc_hd__fill_8_169 r0 *1 0,0
Xsky130_fd_sc_hd__fill_8_169 VSS VDD VDD sky130_fd_sc_hd__fill_8
* cell instance sky130_fd_sc_hd__fill_8_170 r0 *1 0,0
Xsky130_fd_sc_hd__fill_8_170 VSS VDD VDD sky130_fd_sc_hd__fill_8
* cell instance sky130_fd_sc_hd__fill_8_171 r0 *1 0,0
Xsky130_fd_sc_hd__fill_8_171 VSS VDD VDD sky130_fd_sc_hd__fill_8
* cell instance sky130_fd_sc_hd__fill_8_172 r0 *1 0,0
Xsky130_fd_sc_hd__fill_8_172 VSS VDD VDD sky130_fd_sc_hd__fill_8
* cell instance sky130_fd_sc_hd__fill_8_173 r0 *1 0,0
Xsky130_fd_sc_hd__fill_8_173 VSS VDD VDD sky130_fd_sc_hd__fill_8
* cell instance sky130_fd_sc_hd__fill_8_174 r0 *1 0,0
Xsky130_fd_sc_hd__fill_8_174 VSS VDD VDD sky130_fd_sc_hd__fill_8
* cell instance sky130_fd_sc_hd__fill_8_175 r0 *1 0,0
Xsky130_fd_sc_hd__fill_8_175 VSS VDD VDD sky130_fd_sc_hd__fill_8
* cell instance sky130_fd_sc_hd__fill_8_176 r0 *1 0,0
Xsky130_fd_sc_hd__fill_8_176 VSS VDD VDD sky130_fd_sc_hd__fill_8
* cell instance sky130_fd_sc_hd__fill_8_177 r0 *1 0,0
Xsky130_fd_sc_hd__fill_8_177 VSS VDD VDD sky130_fd_sc_hd__fill_8
* cell instance sky130_fd_sc_hd__fill_8_178 r0 *1 0,0
Xsky130_fd_sc_hd__fill_8_178 VSS VDD VDD sky130_fd_sc_hd__fill_8
* cell instance sky130_fd_sc_hd__fill_8_179 r0 *1 0,0
Xsky130_fd_sc_hd__fill_8_179 VSS VDD VDD sky130_fd_sc_hd__fill_8
* cell instance sky130_fd_sc_hd__fill_8_180 r0 *1 0,0
Xsky130_fd_sc_hd__fill_8_180 VSS VDD VDD sky130_fd_sc_hd__fill_8
* cell instance sky130_fd_sc_hd__fill_8_181 r0 *1 0,0
Xsky130_fd_sc_hd__fill_8_181 VSS VDD VDD sky130_fd_sc_hd__fill_8
* cell instance sky130_fd_sc_hd__fill_8_182 r0 *1 0,0
Xsky130_fd_sc_hd__fill_8_182 VSS VDD VDD sky130_fd_sc_hd__fill_8
* cell instance sky130_fd_sc_hd__fill_8_183 r0 *1 0,0
Xsky130_fd_sc_hd__fill_8_183 VSS VDD VDD sky130_fd_sc_hd__fill_8
* cell instance sky130_fd_sc_hd__fill_8_184 r0 *1 0,0
Xsky130_fd_sc_hd__fill_8_184 VSS VDD VDD sky130_fd_sc_hd__fill_8
* cell instance sky130_fd_sc_hd__fill_8_185 r0 *1 0,0
Xsky130_fd_sc_hd__fill_8_185 VSS VDD VDD sky130_fd_sc_hd__fill_8
* cell instance sky130_fd_sc_hd__fill_8_186 r0 *1 0,0
Xsky130_fd_sc_hd__fill_8_186 VSS VDD VDD sky130_fd_sc_hd__fill_8
* cell instance sky130_fd_sc_hd__fill_8_187 r0 *1 0,0
Xsky130_fd_sc_hd__fill_8_187 VSS VDD VDD sky130_fd_sc_hd__fill_8
* cell instance sky130_fd_sc_hd__fill_8_188 r0 *1 0,0
Xsky130_fd_sc_hd__fill_8_188 VSS VDD VDD sky130_fd_sc_hd__fill_8
* cell instance sky130_fd_sc_hd__fill_8_189 r0 *1 0,0
Xsky130_fd_sc_hd__fill_8_189 VSS VDD VDD sky130_fd_sc_hd__fill_8
* cell instance sky130_fd_sc_hd__fill_8_190 r0 *1 0,0
Xsky130_fd_sc_hd__fill_8_190 VSS VDD VDD sky130_fd_sc_hd__fill_8
* cell instance sky130_fd_sc_hd__fill_8_191 r0 *1 0,0
Xsky130_fd_sc_hd__fill_8_191 VSS VDD VDD sky130_fd_sc_hd__fill_8
* cell instance sky130_fd_sc_hd__fill_8_192 r0 *1 0,0
Xsky130_fd_sc_hd__fill_8_192 VSS VDD VDD sky130_fd_sc_hd__fill_8
* cell instance sky130_fd_sc_hd__fill_8_193 r0 *1 0,0
Xsky130_fd_sc_hd__fill_8_193 VSS VDD VDD sky130_fd_sc_hd__fill_8
* cell instance sky130_fd_sc_hd__fill_8_194 r0 *1 0,0
Xsky130_fd_sc_hd__fill_8_194 VSS VDD VDD sky130_fd_sc_hd__fill_8
* cell instance sky130_fd_sc_hd__fill_8_195 r0 *1 0,0
Xsky130_fd_sc_hd__fill_8_195 VSS VDD VDD sky130_fd_sc_hd__fill_8
* cell instance sky130_fd_sc_hd__fill_8_196 r0 *1 0,0
Xsky130_fd_sc_hd__fill_8_196 VSS VDD VDD sky130_fd_sc_hd__fill_8
* cell instance sky130_fd_sc_hd__fill_8_197 r0 *1 0,0
Xsky130_fd_sc_hd__fill_8_197 VSS VDD VDD sky130_fd_sc_hd__fill_8
* cell instance sky130_fd_sc_hd__fill_8_198 r0 *1 0,0
Xsky130_fd_sc_hd__fill_8_198 VSS VDD VDD sky130_fd_sc_hd__fill_8
* cell instance sky130_fd_sc_hd__fill_8_199 r0 *1 0,0
Xsky130_fd_sc_hd__fill_8_199 VSS VDD VDD sky130_fd_sc_hd__fill_8
* cell instance sky130_fd_sc_hd__fill_8_200 r0 *1 0,0
Xsky130_fd_sc_hd__fill_8_200 VSS VDD VDD sky130_fd_sc_hd__fill_8
* cell instance sky130_fd_sc_hd__fill_8_201 r0 *1 0,0
Xsky130_fd_sc_hd__fill_8_201 VSS VDD VDD sky130_fd_sc_hd__fill_8
* cell instance sky130_fd_sc_hd__fill_8_202 r0 *1 0,0
Xsky130_fd_sc_hd__fill_8_202 VSS VDD VDD sky130_fd_sc_hd__fill_8
* cell instance sky130_fd_sc_hd__fill_8_203 r0 *1 0,0
Xsky130_fd_sc_hd__fill_8_203 VSS VDD VDD sky130_fd_sc_hd__fill_8
* cell instance sky130_fd_sc_hd__fill_8_204 r0 *1 0,0
Xsky130_fd_sc_hd__fill_8_204 VSS VDD VDD sky130_fd_sc_hd__fill_8
* cell instance sky130_fd_sc_hd__fill_8_205 r0 *1 0,0
Xsky130_fd_sc_hd__fill_8_205 VSS VDD VDD sky130_fd_sc_hd__fill_8
* cell instance sky130_fd_sc_hd__fill_8_206 r0 *1 0,0
Xsky130_fd_sc_hd__fill_8_206 VSS VDD VDD sky130_fd_sc_hd__fill_8
* cell instance sky130_fd_sc_hd__fill_8_207 r0 *1 0,0
Xsky130_fd_sc_hd__fill_8_207 VSS VDD VDD sky130_fd_sc_hd__fill_8
* cell instance sky130_fd_sc_hd__fill_8_208 r0 *1 0,0
Xsky130_fd_sc_hd__fill_8_208 VSS VDD VDD sky130_fd_sc_hd__fill_8
* cell instance sky130_fd_sc_hd__fill_8_209 r0 *1 0,0
Xsky130_fd_sc_hd__fill_8_209 VSS VDD VDD sky130_fd_sc_hd__fill_8
* cell instance sky130_fd_sc_hd__fill_8_210 r0 *1 0,0
Xsky130_fd_sc_hd__fill_8_210 VSS VDD VDD sky130_fd_sc_hd__fill_8
* cell instance sky130_fd_sc_hd__fill_8_211 r0 *1 0,0
Xsky130_fd_sc_hd__fill_8_211 VSS VDD VDD sky130_fd_sc_hd__fill_8
* cell instance sky130_fd_sc_hd__fill_8_212 r0 *1 0,0
Xsky130_fd_sc_hd__fill_8_212 VSS VDD VDD sky130_fd_sc_hd__fill_8
* cell instance sky130_fd_sc_hd__fill_8_213 r0 *1 0,0
Xsky130_fd_sc_hd__fill_8_213 VSS VDD VDD sky130_fd_sc_hd__fill_8
* cell instance sky130_fd_sc_hd__fill_8_214 r0 *1 0,0
Xsky130_fd_sc_hd__fill_8_214 VSS VDD VDD sky130_fd_sc_hd__fill_8
* cell instance sky130_fd_sc_hd__fill_8_215 r0 *1 0,0
Xsky130_fd_sc_hd__fill_8_215 VSS VDD VDD sky130_fd_sc_hd__fill_8
* cell instance sky130_fd_sc_hd__fill_8_216 r0 *1 0,0
Xsky130_fd_sc_hd__fill_8_216 VSS VDD VDD sky130_fd_sc_hd__fill_8
* cell instance sky130_fd_sc_hd__fill_8_217 r0 *1 0,0
Xsky130_fd_sc_hd__fill_8_217 VSS VDD VDD sky130_fd_sc_hd__fill_8
* cell instance sky130_fd_sc_hd__fill_8_218 r0 *1 0,0
Xsky130_fd_sc_hd__fill_8_218 VSS VDD VDD sky130_fd_sc_hd__fill_8
* cell instance sky130_fd_sc_hd__fill_8_219 r0 *1 0,0
Xsky130_fd_sc_hd__fill_8_219 VSS VDD VDD sky130_fd_sc_hd__fill_8
* cell instance sky130_fd_sc_hd__fill_8_220 r0 *1 0,0
Xsky130_fd_sc_hd__fill_8_220 VSS VDD VDD sky130_fd_sc_hd__fill_8
* cell instance sky130_fd_sc_hd__fill_8_221 r0 *1 0,0
Xsky130_fd_sc_hd__fill_8_221 VSS VDD VDD sky130_fd_sc_hd__fill_8
* cell instance sky130_fd_sc_hd__fill_8_222 r0 *1 0,0
Xsky130_fd_sc_hd__fill_8_222 VSS VDD VDD sky130_fd_sc_hd__fill_8
* cell instance sky130_fd_sc_hd__fill_8_223 r0 *1 0,0
Xsky130_fd_sc_hd__fill_8_223 VSS VDD VDD sky130_fd_sc_hd__fill_8
* cell instance sky130_fd_sc_hd__fill_8_224 r0 *1 0,0
Xsky130_fd_sc_hd__fill_8_224 VSS VDD VDD sky130_fd_sc_hd__fill_8
* cell instance sky130_fd_sc_hd__fill_8_225 r0 *1 0,0
Xsky130_fd_sc_hd__fill_8_225 VSS VDD VDD sky130_fd_sc_hd__fill_8
* cell instance sky130_fd_sc_hd__fill_8_226 r0 *1 0,0
Xsky130_fd_sc_hd__fill_8_226 VSS VDD VDD sky130_fd_sc_hd__fill_8
* cell instance sky130_fd_sc_hd__fill_8_227 r0 *1 0,0
Xsky130_fd_sc_hd__fill_8_227 VSS VDD VDD sky130_fd_sc_hd__fill_8
* cell instance sky130_fd_sc_hd__fill_8_228 r0 *1 0,0
Xsky130_fd_sc_hd__fill_8_228 VSS VDD VDD sky130_fd_sc_hd__fill_8
* cell instance sky130_fd_sc_hd__fill_8_229 r0 *1 0,0
Xsky130_fd_sc_hd__fill_8_229 VSS VDD VDD sky130_fd_sc_hd__fill_8
* cell instance sky130_fd_sc_hd__fill_8_230 r0 *1 0,0
Xsky130_fd_sc_hd__fill_8_230 VSS VDD VDD sky130_fd_sc_hd__fill_8
* cell instance sky130_fd_sc_hd__fill_8_231 r0 *1 0,0
Xsky130_fd_sc_hd__fill_8_231 VSS VDD VDD sky130_fd_sc_hd__fill_8
* cell instance sky130_fd_sc_hd__fill_8_232 r0 *1 0,0
Xsky130_fd_sc_hd__fill_8_232 VSS VDD VDD sky130_fd_sc_hd__fill_8
* cell instance sky130_fd_sc_hd__fill_8_233 r0 *1 0,0
Xsky130_fd_sc_hd__fill_8_233 VSS VDD VDD sky130_fd_sc_hd__fill_8
* cell instance sky130_fd_sc_hd__fill_8_234 r0 *1 0,0
Xsky130_fd_sc_hd__fill_8_234 VSS VDD VDD sky130_fd_sc_hd__fill_8
* cell instance sky130_fd_sc_hd__fill_8_235 r0 *1 0,0
Xsky130_fd_sc_hd__fill_8_235 VSS VDD VDD sky130_fd_sc_hd__fill_8
* cell instance sky130_fd_sc_hd__fill_8_236 r0 *1 0,0
Xsky130_fd_sc_hd__fill_8_236 VSS VDD VDD sky130_fd_sc_hd__fill_8
* cell instance sky130_fd_sc_hd__fill_8_237 r0 *1 0,0
Xsky130_fd_sc_hd__fill_8_237 VSS VDD VDD sky130_fd_sc_hd__fill_8
* cell instance sky130_fd_sc_hd__fill_8_238 r0 *1 0,0
Xsky130_fd_sc_hd__fill_8_238 VSS VDD VDD sky130_fd_sc_hd__fill_8
* cell instance sky130_fd_sc_hd__fill_8_239 r0 *1 0,0
Xsky130_fd_sc_hd__fill_8_239 VSS VDD VDD sky130_fd_sc_hd__fill_8
* cell instance sky130_fd_sc_hd__fill_8_240 r0 *1 0,0
Xsky130_fd_sc_hd__fill_8_240 VSS VDD VDD sky130_fd_sc_hd__fill_8
* cell instance sky130_fd_sc_hd__fill_8_241 r0 *1 0,0
Xsky130_fd_sc_hd__fill_8_241 VSS VDD VDD sky130_fd_sc_hd__fill_8
* cell instance sky130_fd_sc_hd__fill_8_242 r0 *1 0,0
Xsky130_fd_sc_hd__fill_8_242 VSS VDD VDD sky130_fd_sc_hd__fill_8
* cell instance sky130_fd_sc_hd__fill_8_243 r0 *1 0,0
Xsky130_fd_sc_hd__fill_8_243 VSS VDD VDD sky130_fd_sc_hd__fill_8
* cell instance sky130_fd_sc_hd__fill_8_244 r0 *1 0,0
Xsky130_fd_sc_hd__fill_8_244 VSS VDD VDD sky130_fd_sc_hd__fill_8
* cell instance sky130_fd_sc_hd__fill_8_245 r0 *1 0,0
Xsky130_fd_sc_hd__fill_8_245 VSS VDD VDD sky130_fd_sc_hd__fill_8
* cell instance sky130_fd_sc_hd__fill_8_246 r0 *1 0,0
Xsky130_fd_sc_hd__fill_8_246 VSS VDD VDD sky130_fd_sc_hd__fill_8
* cell instance sky130_fd_sc_hd__fill_8_247 r0 *1 0,0
Xsky130_fd_sc_hd__fill_8_247 VSS VDD VDD sky130_fd_sc_hd__fill_8
* cell instance sky130_fd_sc_hd__fill_8_248 r0 *1 0,0
Xsky130_fd_sc_hd__fill_8_248 VSS VDD VDD sky130_fd_sc_hd__fill_8
* cell instance sky130_fd_sc_hd__fill_8_249 r0 *1 0,0
Xsky130_fd_sc_hd__fill_8_249 VSS VDD VDD sky130_fd_sc_hd__fill_8
* cell instance sky130_fd_sc_hd__fill_8_250 r0 *1 0,0
Xsky130_fd_sc_hd__fill_8_250 VSS VDD VDD sky130_fd_sc_hd__fill_8
* cell instance sky130_fd_sc_hd__fill_8_251 r0 *1 0,0
Xsky130_fd_sc_hd__fill_8_251 VSS VDD VDD sky130_fd_sc_hd__fill_8
* cell instance sky130_fd_sc_hd__fill_8_252 r0 *1 0,0
Xsky130_fd_sc_hd__fill_8_252 VSS VDD VDD sky130_fd_sc_hd__fill_8
* cell instance sky130_fd_sc_hd__fill_8_253 r0 *1 0,0
Xsky130_fd_sc_hd__fill_8_253 VSS VDD VDD sky130_fd_sc_hd__fill_8
* cell instance sky130_fd_sc_hd__fill_8_254 r0 *1 0,0
Xsky130_fd_sc_hd__fill_8_254 VSS VDD VDD sky130_fd_sc_hd__fill_8
* cell instance sky130_fd_sc_hd__fill_8_255 r0 *1 0,0
Xsky130_fd_sc_hd__fill_8_255 VSS VDD VDD sky130_fd_sc_hd__fill_8
* cell instance sky130_fd_sc_hd__fill_8_256 r0 *1 0,0
Xsky130_fd_sc_hd__fill_8_256 VSS VDD VDD sky130_fd_sc_hd__fill_8
* cell instance sky130_fd_sc_hd__fill_8_257 r0 *1 0,0
Xsky130_fd_sc_hd__fill_8_257 VSS VDD VDD sky130_fd_sc_hd__fill_8
* cell instance sky130_fd_sc_hd__fill_8_258 r0 *1 0,0
Xsky130_fd_sc_hd__fill_8_258 VSS VDD VDD sky130_fd_sc_hd__fill_8
* cell instance sky130_fd_sc_hd__fill_8_259 r0 *1 0,0
Xsky130_fd_sc_hd__fill_8_259 VSS VDD VDD sky130_fd_sc_hd__fill_8
* cell instance sky130_fd_sc_hd__fill_8_260 r0 *1 0,0
Xsky130_fd_sc_hd__fill_8_260 VSS VDD VDD sky130_fd_sc_hd__fill_8
* cell instance sky130_fd_sc_hd__fill_8_261 r0 *1 0,0
Xsky130_fd_sc_hd__fill_8_261 VSS VDD VDD sky130_fd_sc_hd__fill_8
* cell instance sky130_fd_sc_hd__fill_8_262 r0 *1 0,0
Xsky130_fd_sc_hd__fill_8_262 VSS VDD VDD sky130_fd_sc_hd__fill_8
* cell instance sky130_fd_sc_hd__fill_8_263 r0 *1 0,0
Xsky130_fd_sc_hd__fill_8_263 VSS VDD VDD sky130_fd_sc_hd__fill_8
* cell instance sky130_fd_sc_hd__fill_8_264 r0 *1 0,0
Xsky130_fd_sc_hd__fill_8_264 VSS VDD VDD sky130_fd_sc_hd__fill_8
* cell instance sky130_fd_sc_hd__fill_8_265 r0 *1 0,0
Xsky130_fd_sc_hd__fill_8_265 VSS VDD VDD sky130_fd_sc_hd__fill_8
* cell instance sky130_fd_sc_hd__fill_8_266 r0 *1 0,0
Xsky130_fd_sc_hd__fill_8_266 VSS VDD VDD sky130_fd_sc_hd__fill_8
* cell instance sky130_fd_sc_hd__fill_8_267 r0 *1 0,0
Xsky130_fd_sc_hd__fill_8_267 VSS VDD VDD sky130_fd_sc_hd__fill_8
* cell instance sky130_fd_sc_hd__fill_8_268 r0 *1 0,0
Xsky130_fd_sc_hd__fill_8_268 VSS VDD VDD sky130_fd_sc_hd__fill_8
* cell instance sky130_fd_sc_hd__fill_8_269 r0 *1 0,0
Xsky130_fd_sc_hd__fill_8_269 VSS VDD VDD sky130_fd_sc_hd__fill_8
* cell instance sky130_fd_sc_hd__fill_8_270 r0 *1 0,0
Xsky130_fd_sc_hd__fill_8_270 VSS VDD VDD sky130_fd_sc_hd__fill_8
* cell instance sky130_fd_sc_hd__fill_8_271 r0 *1 0,0
Xsky130_fd_sc_hd__fill_8_271 VSS VDD VDD sky130_fd_sc_hd__fill_8
* cell instance sky130_fd_sc_hd__fill_8_272 r0 *1 0,0
Xsky130_fd_sc_hd__fill_8_272 VSS VDD VDD sky130_fd_sc_hd__fill_8
* cell instance sky130_fd_sc_hd__fill_8_273 r0 *1 0,0
Xsky130_fd_sc_hd__fill_8_273 VSS VDD VDD sky130_fd_sc_hd__fill_8
* cell instance sky130_fd_sc_hd__fill_8_274 r0 *1 0,0
Xsky130_fd_sc_hd__fill_8_274 VSS VDD VDD sky130_fd_sc_hd__fill_8
* cell instance sky130_fd_sc_hd__fill_8_275 r0 *1 0,0
Xsky130_fd_sc_hd__fill_8_275 VSS VDD VDD sky130_fd_sc_hd__fill_8
* cell instance sky130_fd_sc_hd__fill_8_276 r0 *1 0,0
Xsky130_fd_sc_hd__fill_8_276 VSS VDD VDD sky130_fd_sc_hd__fill_8
* cell instance sky130_fd_sc_hd__fill_8_277 r0 *1 0,0
Xsky130_fd_sc_hd__fill_8_277 VSS VDD VDD sky130_fd_sc_hd__fill_8
* cell instance sky130_fd_sc_hd__fill_8_278 r0 *1 0,0
Xsky130_fd_sc_hd__fill_8_278 VSS VDD VDD sky130_fd_sc_hd__fill_8
* cell instance sky130_fd_sc_hd__fill_8_279 r0 *1 0,0
Xsky130_fd_sc_hd__fill_8_279 VSS VDD VDD sky130_fd_sc_hd__fill_8
* cell instance sky130_fd_sc_hd__fill_8_280 r0 *1 0,0
Xsky130_fd_sc_hd__fill_8_280 VSS VDD VDD sky130_fd_sc_hd__fill_8
* cell instance sky130_fd_sc_hd__fill_8_281 r0 *1 0,0
Xsky130_fd_sc_hd__fill_8_281 VSS VDD VDD sky130_fd_sc_hd__fill_8
* cell instance sky130_fd_sc_hd__fill_8_282 r0 *1 0,0
Xsky130_fd_sc_hd__fill_8_282 VSS VDD VDD sky130_fd_sc_hd__fill_8
* cell instance sky130_fd_sc_hd__fill_8_283 r0 *1 0,0
Xsky130_fd_sc_hd__fill_8_283 VSS VDD VDD sky130_fd_sc_hd__fill_8
* cell instance sky130_fd_sc_hd__fill_8_284 r0 *1 0,0
Xsky130_fd_sc_hd__fill_8_284 VSS VDD VDD sky130_fd_sc_hd__fill_8
* cell instance sky130_fd_sc_hd__fill_8_285 r0 *1 0,0
Xsky130_fd_sc_hd__fill_8_285 VSS VDD VDD sky130_fd_sc_hd__fill_8
* cell instance sky130_fd_sc_hd__fill_8_286 r0 *1 0,0
Xsky130_fd_sc_hd__fill_8_286 VSS VDD VDD sky130_fd_sc_hd__fill_8
* cell instance sky130_fd_sc_hd__fill_8_287 r0 *1 0,0
Xsky130_fd_sc_hd__fill_8_287 VSS VDD VDD sky130_fd_sc_hd__fill_8
* cell instance sky130_fd_sc_hd__fill_8_288 r0 *1 0,0
Xsky130_fd_sc_hd__fill_8_288 VSS VDD VDD sky130_fd_sc_hd__fill_8
* cell instance sky130_fd_sc_hd__fill_8_289 r0 *1 0,0
Xsky130_fd_sc_hd__fill_8_289 VSS VDD VDD sky130_fd_sc_hd__fill_8
* cell instance sky130_fd_sc_hd__fill_8_290 r0 *1 0,0
Xsky130_fd_sc_hd__fill_8_290 VSS VDD VDD sky130_fd_sc_hd__fill_8
* cell instance sky130_fd_sc_hd__fill_8_291 r0 *1 0,0
Xsky130_fd_sc_hd__fill_8_291 VSS VDD VDD sky130_fd_sc_hd__fill_8
* cell instance sky130_fd_sc_hd__fill_8_292 r0 *1 0,0
Xsky130_fd_sc_hd__fill_8_292 VSS VDD VDD sky130_fd_sc_hd__fill_8
* cell instance sky130_fd_sc_hd__fill_8_293 r0 *1 0,0
Xsky130_fd_sc_hd__fill_8_293 VSS VDD VDD sky130_fd_sc_hd__fill_8
* cell instance sky130_fd_sc_hd__fill_8_294 r0 *1 0,0
Xsky130_fd_sc_hd__fill_8_294 VSS VDD VDD sky130_fd_sc_hd__fill_8
* cell instance sky130_fd_sc_hd__fill_8_295 r0 *1 0,0
Xsky130_fd_sc_hd__fill_8_295 VSS VDD VDD sky130_fd_sc_hd__fill_8
* cell instance sky130_fd_sc_hd__fill_8_296 r0 *1 0,0
Xsky130_fd_sc_hd__fill_8_296 VSS VDD VDD sky130_fd_sc_hd__fill_8
* cell instance sky130_fd_sc_hd__fill_8_297 r0 *1 0,0
Xsky130_fd_sc_hd__fill_8_297 VSS VDD VDD sky130_fd_sc_hd__fill_8
* cell instance sky130_fd_sc_hd__fill_8_298 r0 *1 0,0
Xsky130_fd_sc_hd__fill_8_298 VSS VDD VDD sky130_fd_sc_hd__fill_8
* cell instance sky130_fd_sc_hd__fill_8_299 r0 *1 0,0
Xsky130_fd_sc_hd__fill_8_299 VSS VDD VDD sky130_fd_sc_hd__fill_8
* cell instance sky130_fd_sc_hd__fill_8_300 r0 *1 0,0
Xsky130_fd_sc_hd__fill_8_300 VSS VDD VDD sky130_fd_sc_hd__fill_8
* cell instance sky130_fd_sc_hd__fill_8_301 r0 *1 0,0
Xsky130_fd_sc_hd__fill_8_301 VSS VDD VDD sky130_fd_sc_hd__fill_8
* cell instance sky130_fd_sc_hd__fill_8_302 r0 *1 0,0
Xsky130_fd_sc_hd__fill_8_302 VSS VDD VDD sky130_fd_sc_hd__fill_8
* cell instance sky130_fd_sc_hd__fill_8_303 r0 *1 0,0
Xsky130_fd_sc_hd__fill_8_303 VSS VDD VDD sky130_fd_sc_hd__fill_8
* cell instance sky130_fd_sc_hd__fill_8_304 r0 *1 0,0
Xsky130_fd_sc_hd__fill_8_304 VSS VDD VDD sky130_fd_sc_hd__fill_8
* cell instance sky130_fd_sc_hd__fill_8_305 r0 *1 0,0
Xsky130_fd_sc_hd__fill_8_305 VSS VDD VDD sky130_fd_sc_hd__fill_8
* cell instance sky130_fd_sc_hd__fill_8_306 r0 *1 0,0
Xsky130_fd_sc_hd__fill_8_306 VSS VDD VDD sky130_fd_sc_hd__fill_8
* cell instance sky130_fd_sc_hd__fill_8_307 r0 *1 0,0
Xsky130_fd_sc_hd__fill_8_307 VSS VDD VDD sky130_fd_sc_hd__fill_8
* cell instance sky130_fd_sc_hd__fill_8_308 r0 *1 0,0
Xsky130_fd_sc_hd__fill_8_308 VSS VDD VDD sky130_fd_sc_hd__fill_8
* cell instance sky130_fd_sc_hd__fill_8_309 r0 *1 0,0
Xsky130_fd_sc_hd__fill_8_309 VSS VDD VDD sky130_fd_sc_hd__fill_8
* cell instance sky130_fd_sc_hd__fill_8_310 r0 *1 0,0
Xsky130_fd_sc_hd__fill_8_310 VSS VDD VDD sky130_fd_sc_hd__fill_8
* cell instance sky130_fd_sc_hd__fill_8_311 r0 *1 0,0
Xsky130_fd_sc_hd__fill_8_311 VSS VDD VDD sky130_fd_sc_hd__fill_8
* cell instance sky130_fd_sc_hd__fill_8_312 r0 *1 0,0
Xsky130_fd_sc_hd__fill_8_312 VSS VDD VDD sky130_fd_sc_hd__fill_8
* cell instance sky130_fd_sc_hd__fill_8_313 r0 *1 0,0
Xsky130_fd_sc_hd__fill_8_313 VSS VDD VDD sky130_fd_sc_hd__fill_8
* cell instance sky130_fd_sc_hd__fill_8_314 r0 *1 0,0
Xsky130_fd_sc_hd__fill_8_314 VSS VDD VDD sky130_fd_sc_hd__fill_8
* cell instance sky130_fd_sc_hd__fill_8_315 r0 *1 0,0
Xsky130_fd_sc_hd__fill_8_315 VSS VDD VDD sky130_fd_sc_hd__fill_8
* cell instance sky130_fd_sc_hd__fill_8_316 r0 *1 0,0
Xsky130_fd_sc_hd__fill_8_316 VSS VDD VDD sky130_fd_sc_hd__fill_8
* cell instance sky130_fd_sc_hd__fill_8_317 r0 *1 0,0
Xsky130_fd_sc_hd__fill_8_317 VSS VDD VDD sky130_fd_sc_hd__fill_8
* cell instance sky130_fd_sc_hd__fill_8_318 r0 *1 0,0
Xsky130_fd_sc_hd__fill_8_318 VSS VDD VDD sky130_fd_sc_hd__fill_8
* cell instance sky130_fd_sc_hd__fill_8_319 r0 *1 0,0
Xsky130_fd_sc_hd__fill_8_319 VSS VDD VDD sky130_fd_sc_hd__fill_8
* cell instance sky130_fd_sc_hd__fill_8_320 r0 *1 0,0
Xsky130_fd_sc_hd__fill_8_320 VSS VDD VDD sky130_fd_sc_hd__fill_8
* cell instance sky130_fd_sc_hd__fill_8_321 r0 *1 0,0
Xsky130_fd_sc_hd__fill_8_321 VSS VDD VDD sky130_fd_sc_hd__fill_8
* cell instance sky130_fd_sc_hd__fill_8_322 r0 *1 0,0
Xsky130_fd_sc_hd__fill_8_322 VSS VDD VDD sky130_fd_sc_hd__fill_8
* cell instance sky130_fd_sc_hd__fill_8_323 r0 *1 0,0
Xsky130_fd_sc_hd__fill_8_323 VSS VDD VDD sky130_fd_sc_hd__fill_8
* cell instance sky130_fd_sc_hd__fill_8_324 r0 *1 0,0
Xsky130_fd_sc_hd__fill_8_324 VSS VDD VDD sky130_fd_sc_hd__fill_8
* cell instance sky130_fd_sc_hd__fill_8_325 r0 *1 0,0
Xsky130_fd_sc_hd__fill_8_325 VSS VDD VDD sky130_fd_sc_hd__fill_8
* cell instance sky130_fd_sc_hd__fill_8_326 r0 *1 0,0
Xsky130_fd_sc_hd__fill_8_326 VSS VDD VDD sky130_fd_sc_hd__fill_8
* cell instance sky130_fd_sc_hd__fill_8_327 r0 *1 0,0
Xsky130_fd_sc_hd__fill_8_327 VSS VDD VDD sky130_fd_sc_hd__fill_8
* cell instance sky130_fd_sc_hd__fill_8_328 r0 *1 0,0
Xsky130_fd_sc_hd__fill_8_328 VSS VDD VDD sky130_fd_sc_hd__fill_8
* cell instance sky130_fd_sc_hd__fill_8_329 r0 *1 0,0
Xsky130_fd_sc_hd__fill_8_329 VSS VDD VDD sky130_fd_sc_hd__fill_8
* cell instance sky130_fd_sc_hd__fill_8_330 r0 *1 0,0
Xsky130_fd_sc_hd__fill_8_330 VSS VDD VDD sky130_fd_sc_hd__fill_8
* cell instance sky130_fd_sc_hd__fill_8_331 r0 *1 0,0
Xsky130_fd_sc_hd__fill_8_331 VSS VDD VDD sky130_fd_sc_hd__fill_8
* cell instance sky130_fd_sc_hd__fill_8_332 r0 *1 0,0
Xsky130_fd_sc_hd__fill_8_332 VSS VDD VDD sky130_fd_sc_hd__fill_8
* cell instance sky130_fd_sc_hd__fill_8_333 r0 *1 0,0
Xsky130_fd_sc_hd__fill_8_333 VSS VDD VDD sky130_fd_sc_hd__fill_8
* cell instance sky130_fd_sc_hd__fill_8_334 r0 *1 0,0
Xsky130_fd_sc_hd__fill_8_334 VSS VDD VDD sky130_fd_sc_hd__fill_8
* cell instance sky130_fd_sc_hd__fill_8_335 r0 *1 0,0
Xsky130_fd_sc_hd__fill_8_335 VSS VDD VDD sky130_fd_sc_hd__fill_8
* cell instance sky130_fd_sc_hd__fill_8_336 r0 *1 0,0
Xsky130_fd_sc_hd__fill_8_336 VSS VDD VDD sky130_fd_sc_hd__fill_8
* cell instance sky130_fd_sc_hd__fill_8_337 r0 *1 0,0
Xsky130_fd_sc_hd__fill_8_337 VSS VDD VDD sky130_fd_sc_hd__fill_8
* cell instance sky130_fd_sc_hd__fill_8_338 r0 *1 0,0
Xsky130_fd_sc_hd__fill_8_338 VSS VDD VDD sky130_fd_sc_hd__fill_8
* cell instance sky130_fd_sc_hd__fill_8_339 r0 *1 0,0
Xsky130_fd_sc_hd__fill_8_339 VSS VDD VDD sky130_fd_sc_hd__fill_8
* cell instance sky130_fd_sc_hd__fill_8_340 r0 *1 0,0
Xsky130_fd_sc_hd__fill_8_340 VSS VDD VDD sky130_fd_sc_hd__fill_8
* cell instance sky130_fd_sc_hd__fill_8_341 r0 *1 0,0
Xsky130_fd_sc_hd__fill_8_341 VSS VDD VDD sky130_fd_sc_hd__fill_8
* cell instance sky130_fd_sc_hd__fill_8_342 r0 *1 0,0
Xsky130_fd_sc_hd__fill_8_342 VSS VDD VDD sky130_fd_sc_hd__fill_8
* cell instance sky130_fd_sc_hd__fill_8_343 r0 *1 0,0
Xsky130_fd_sc_hd__fill_8_343 VSS VDD VDD sky130_fd_sc_hd__fill_8
* cell instance sky130_fd_sc_hd__fill_8_344 r0 *1 0,0
Xsky130_fd_sc_hd__fill_8_344 VSS VDD VDD sky130_fd_sc_hd__fill_8
* cell instance sky130_fd_sc_hd__fill_8_345 r0 *1 0,0
Xsky130_fd_sc_hd__fill_8_345 VSS VDD VDD sky130_fd_sc_hd__fill_8
* cell instance sky130_fd_sc_hd__fill_8_346 r0 *1 0,0
Xsky130_fd_sc_hd__fill_8_346 VSS VDD VDD sky130_fd_sc_hd__fill_8
* cell instance sky130_fd_sc_hd__fill_8_347 r0 *1 0,0
Xsky130_fd_sc_hd__fill_8_347 VSS VDD VDD sky130_fd_sc_hd__fill_8
* cell instance sky130_fd_sc_hd__fill_8_348 r0 *1 0,0
Xsky130_fd_sc_hd__fill_8_348 VSS VDD VDD sky130_fd_sc_hd__fill_8
* cell instance sky130_fd_sc_hd__fill_8_349 r0 *1 0,0
Xsky130_fd_sc_hd__fill_8_349 VSS VDD VDD sky130_fd_sc_hd__fill_8
* cell instance sky130_fd_sc_hd__fill_8_350 r0 *1 0,0
Xsky130_fd_sc_hd__fill_8_350 VSS VDD VDD sky130_fd_sc_hd__fill_8
* cell instance sky130_fd_sc_hd__fill_8_351 r0 *1 0,0
Xsky130_fd_sc_hd__fill_8_351 VSS VDD VDD sky130_fd_sc_hd__fill_8
* cell instance sky130_fd_sc_hd__fill_8_352 r0 *1 0,0
Xsky130_fd_sc_hd__fill_8_352 VSS VDD VDD sky130_fd_sc_hd__fill_8
* cell instance sky130_fd_sc_hd__fill_8_353 r0 *1 0,0
Xsky130_fd_sc_hd__fill_8_353 VSS VDD VDD sky130_fd_sc_hd__fill_8
* cell instance sky130_fd_sc_hd__fill_8_354 r0 *1 0,0
Xsky130_fd_sc_hd__fill_8_354 VSS VDD VDD sky130_fd_sc_hd__fill_8
* cell instance sky130_fd_sc_hd__fill_8_355 r0 *1 0,0
Xsky130_fd_sc_hd__fill_8_355 VSS VDD VDD sky130_fd_sc_hd__fill_8
* cell instance sky130_fd_sc_hd__fill_8_356 r0 *1 0,0
Xsky130_fd_sc_hd__fill_8_356 VSS VDD VDD sky130_fd_sc_hd__fill_8
* cell instance sky130_fd_sc_hd__fill_8_357 r0 *1 0,0
Xsky130_fd_sc_hd__fill_8_357 VSS VDD VDD sky130_fd_sc_hd__fill_8
* cell instance sky130_fd_sc_hd__fill_8_358 r0 *1 0,0
Xsky130_fd_sc_hd__fill_8_358 VSS VDD VDD sky130_fd_sc_hd__fill_8
* cell instance sky130_fd_sc_hd__fill_8_359 r0 *1 0,0
Xsky130_fd_sc_hd__fill_8_359 VSS VDD VDD sky130_fd_sc_hd__fill_8
* cell instance sky130_fd_sc_hd__fill_8_360 r0 *1 0,0
Xsky130_fd_sc_hd__fill_8_360 VSS VDD VDD sky130_fd_sc_hd__fill_8
* cell instance sky130_fd_sc_hd__fill_8_361 r0 *1 0,0
Xsky130_fd_sc_hd__fill_8_361 VSS VDD VDD sky130_fd_sc_hd__fill_8
* cell instance sky130_fd_sc_hd__fill_8_362 r0 *1 0,0
Xsky130_fd_sc_hd__fill_8_362 VSS VDD VDD sky130_fd_sc_hd__fill_8
* cell instance sky130_fd_sc_hd__fill_8_363 r0 *1 0,0
Xsky130_fd_sc_hd__fill_8_363 VSS VDD VDD sky130_fd_sc_hd__fill_8
* cell instance sky130_fd_sc_hd__fill_8_364 r0 *1 0,0
Xsky130_fd_sc_hd__fill_8_364 VSS VDD VDD sky130_fd_sc_hd__fill_8
* cell instance sky130_fd_sc_hd__fill_8_365 r0 *1 0,0
Xsky130_fd_sc_hd__fill_8_365 VSS VDD VDD sky130_fd_sc_hd__fill_8
* cell instance sky130_fd_sc_hd__fill_8_366 r0 *1 0,0
Xsky130_fd_sc_hd__fill_8_366 VSS VDD VDD sky130_fd_sc_hd__fill_8
* cell instance sky130_fd_sc_hd__fill_8_367 r0 *1 0,0
Xsky130_fd_sc_hd__fill_8_367 VSS VDD VDD sky130_fd_sc_hd__fill_8
* cell instance sky130_fd_sc_hd__fill_8_368 r0 *1 0,0
Xsky130_fd_sc_hd__fill_8_368 VSS VDD VDD sky130_fd_sc_hd__fill_8
* cell instance sky130_fd_sc_hd__fill_8_369 r0 *1 0,0
Xsky130_fd_sc_hd__fill_8_369 VSS VDD VDD sky130_fd_sc_hd__fill_8
* cell instance sky130_fd_sc_hd__fill_8_370 r0 *1 0,0
Xsky130_fd_sc_hd__fill_8_370 VSS VDD VDD sky130_fd_sc_hd__fill_8
* cell instance sky130_fd_sc_hd__fill_8_371 r0 *1 0,0
Xsky130_fd_sc_hd__fill_8_371 VSS VDD VDD sky130_fd_sc_hd__fill_8
* cell instance sky130_fd_sc_hd__fill_8_372 r0 *1 0,0
Xsky130_fd_sc_hd__fill_8_372 VSS VDD VDD sky130_fd_sc_hd__fill_8
* cell instance sky130_fd_sc_hd__fill_8_373 r0 *1 0,0
Xsky130_fd_sc_hd__fill_8_373 VSS VDD VDD sky130_fd_sc_hd__fill_8
* cell instance sky130_fd_sc_hd__fill_8_374 r0 *1 0,0
Xsky130_fd_sc_hd__fill_8_374 VSS VDD VDD sky130_fd_sc_hd__fill_8
* cell instance sky130_fd_sc_hd__fill_8_375 r0 *1 0,0
Xsky130_fd_sc_hd__fill_8_375 VSS VDD VDD sky130_fd_sc_hd__fill_8
* cell instance sky130_fd_sc_hd__fill_8_376 r0 *1 0,0
Xsky130_fd_sc_hd__fill_8_376 VSS VDD VDD sky130_fd_sc_hd__fill_8
* cell instance sky130_fd_sc_hd__fill_8_377 r0 *1 0,0
Xsky130_fd_sc_hd__fill_8_377 VSS VDD VDD sky130_fd_sc_hd__fill_8
* cell instance sky130_fd_sc_hd__fill_8_378 r0 *1 0,0
Xsky130_fd_sc_hd__fill_8_378 VSS VDD VDD sky130_fd_sc_hd__fill_8
* cell instance sky130_fd_sc_hd__fill_8_379 r0 *1 0,0
Xsky130_fd_sc_hd__fill_8_379 VSS VDD VDD sky130_fd_sc_hd__fill_8
* cell instance sky130_fd_sc_hd__fill_8_380 r0 *1 0,0
Xsky130_fd_sc_hd__fill_8_380 VSS VDD VDD sky130_fd_sc_hd__fill_8
* cell instance sky130_fd_sc_hd__fill_8_381 r0 *1 0,0
Xsky130_fd_sc_hd__fill_8_381 VSS VDD VDD sky130_fd_sc_hd__fill_8
* cell instance sky130_fd_sc_hd__fill_8_382 r0 *1 0,0
Xsky130_fd_sc_hd__fill_8_382 VSS VDD VDD sky130_fd_sc_hd__fill_8
* cell instance sky130_fd_sc_hd__fill_8_383 r0 *1 0,0
Xsky130_fd_sc_hd__fill_8_383 VSS VDD VDD sky130_fd_sc_hd__fill_8
* cell instance sky130_fd_sc_hd__fill_8_384 r0 *1 0,0
Xsky130_fd_sc_hd__fill_8_384 VSS VDD VDD sky130_fd_sc_hd__fill_8
* cell instance sky130_fd_sc_hd__fill_8_385 r0 *1 0,0
Xsky130_fd_sc_hd__fill_8_385 VSS VDD VDD sky130_fd_sc_hd__fill_8
* cell instance sky130_fd_sc_hd__fill_8_386 r0 *1 0,0
Xsky130_fd_sc_hd__fill_8_386 VSS VDD VDD sky130_fd_sc_hd__fill_8
* cell instance sky130_fd_sc_hd__fill_8_387 r0 *1 0,0
Xsky130_fd_sc_hd__fill_8_387 VSS VDD VDD sky130_fd_sc_hd__fill_8
* cell instance sky130_fd_sc_hd__fill_8_388 r0 *1 0,0
Xsky130_fd_sc_hd__fill_8_388 VSS VDD VDD sky130_fd_sc_hd__fill_8
* cell instance sky130_fd_sc_hd__fill_8_389 r0 *1 0,0
Xsky130_fd_sc_hd__fill_8_389 VSS VDD VDD sky130_fd_sc_hd__fill_8
* cell instance sky130_fd_sc_hd__fill_8_390 r0 *1 0,0
Xsky130_fd_sc_hd__fill_8_390 VSS VDD VDD sky130_fd_sc_hd__fill_8
* cell instance sky130_fd_sc_hd__fill_8_391 r0 *1 0,0
Xsky130_fd_sc_hd__fill_8_391 VSS VDD VDD sky130_fd_sc_hd__fill_8
* cell instance sky130_fd_sc_hd__fill_8_392 r0 *1 0,0
Xsky130_fd_sc_hd__fill_8_392 VSS VDD VDD sky130_fd_sc_hd__fill_8
* cell instance sky130_fd_sc_hd__fill_8_393 r0 *1 0,0
Xsky130_fd_sc_hd__fill_8_393 VSS VDD VDD sky130_fd_sc_hd__fill_8
* cell instance sky130_fd_sc_hd__fill_8_394 r0 *1 0,0
Xsky130_fd_sc_hd__fill_8_394 VSS VDD VDD sky130_fd_sc_hd__fill_8
* cell instance sky130_fd_sc_hd__fill_8_395 r0 *1 0,0
Xsky130_fd_sc_hd__fill_8_395 VSS VDD VDD sky130_fd_sc_hd__fill_8
* cell instance sky130_fd_sc_hd__fill_8_396 r0 *1 0,0
Xsky130_fd_sc_hd__fill_8_396 VSS VDD VDD sky130_fd_sc_hd__fill_8
* cell instance sky130_fd_sc_hd__fill_8_397 r0 *1 0,0
Xsky130_fd_sc_hd__fill_8_397 VSS VDD VDD sky130_fd_sc_hd__fill_8
* cell instance sky130_fd_sc_hd__fill_8_398 r0 *1 0,0
Xsky130_fd_sc_hd__fill_8_398 VSS VDD VDD sky130_fd_sc_hd__fill_8
* cell instance sky130_fd_sc_hd__fill_8_399 r0 *1 0,0
Xsky130_fd_sc_hd__fill_8_399 VSS VDD VDD sky130_fd_sc_hd__fill_8
* cell instance sky130_fd_sc_hd__fill_8_400 r0 *1 0,0
Xsky130_fd_sc_hd__fill_8_400 VSS VDD VDD sky130_fd_sc_hd__fill_8
* cell instance sky130_fd_sc_hd__fill_8_401 r0 *1 0,0
Xsky130_fd_sc_hd__fill_8_401 VSS VDD VDD sky130_fd_sc_hd__fill_8
* cell instance sky130_fd_sc_hd__fill_8_402 r0 *1 0,0
Xsky130_fd_sc_hd__fill_8_402 VSS VDD VDD sky130_fd_sc_hd__fill_8
* cell instance sky130_fd_sc_hd__fill_8_403 r0 *1 0,0
Xsky130_fd_sc_hd__fill_8_403 VSS VDD VDD sky130_fd_sc_hd__fill_8
* cell instance sky130_fd_sc_hd__fill_8_404 r0 *1 0,0
Xsky130_fd_sc_hd__fill_8_404 VSS VDD VDD sky130_fd_sc_hd__fill_8
* cell instance sky130_fd_sc_hd__fill_8_405 r0 *1 0,0
Xsky130_fd_sc_hd__fill_8_405 VSS VDD VDD sky130_fd_sc_hd__fill_8
* cell instance sky130_fd_sc_hd__fill_8_406 r0 *1 0,0
Xsky130_fd_sc_hd__fill_8_406 VSS VDD VDD sky130_fd_sc_hd__fill_8
* cell instance sky130_fd_sc_hd__fill_8_407 r0 *1 0,0
Xsky130_fd_sc_hd__fill_8_407 VSS VDD VDD sky130_fd_sc_hd__fill_8
* cell instance sky130_fd_sc_hd__fill_8_408 r0 *1 0,0
Xsky130_fd_sc_hd__fill_8_408 VSS VDD VDD sky130_fd_sc_hd__fill_8
* cell instance sky130_fd_sc_hd__fill_8_409 r0 *1 0,0
Xsky130_fd_sc_hd__fill_8_409 VSS VDD VDD sky130_fd_sc_hd__fill_8
* cell instance sky130_fd_sc_hd__fill_8_410 r0 *1 0,0
Xsky130_fd_sc_hd__fill_8_410 VSS VDD VDD sky130_fd_sc_hd__fill_8
* cell instance sky130_fd_sc_hd__fill_8_411 r0 *1 0,0
Xsky130_fd_sc_hd__fill_8_411 VSS VDD VDD sky130_fd_sc_hd__fill_8
* cell instance sky130_fd_sc_hd__fill_8_412 r0 *1 0,0
Xsky130_fd_sc_hd__fill_8_412 VSS VDD VDD sky130_fd_sc_hd__fill_8
* cell instance sky130_fd_sc_hd__fill_8_413 r0 *1 0,0
Xsky130_fd_sc_hd__fill_8_413 VSS VDD VDD sky130_fd_sc_hd__fill_8
* cell instance sky130_fd_sc_hd__fill_8_414 r0 *1 0,0
Xsky130_fd_sc_hd__fill_8_414 VSS VDD VDD sky130_fd_sc_hd__fill_8
* cell instance sky130_fd_sc_hd__fill_8_415 r0 *1 0,0
Xsky130_fd_sc_hd__fill_8_415 VSS VDD VDD sky130_fd_sc_hd__fill_8
* cell instance sky130_fd_sc_hd__fill_8_416 r0 *1 0,0
Xsky130_fd_sc_hd__fill_8_416 VSS VDD VDD sky130_fd_sc_hd__fill_8
* cell instance sky130_fd_sc_hd__fill_8_417 r0 *1 0,0
Xsky130_fd_sc_hd__fill_8_417 VSS VDD VDD sky130_fd_sc_hd__fill_8
* cell instance sky130_fd_sc_hd__fill_8_418 r0 *1 0,0
Xsky130_fd_sc_hd__fill_8_418 VSS VDD VDD sky130_fd_sc_hd__fill_8
* cell instance sky130_fd_sc_hd__fill_8_419 r0 *1 0,0
Xsky130_fd_sc_hd__fill_8_419 VSS VDD VDD sky130_fd_sc_hd__fill_8
* cell instance sky130_fd_sc_hd__fill_8_420 r0 *1 0,0
Xsky130_fd_sc_hd__fill_8_420 VSS VDD VDD sky130_fd_sc_hd__fill_8
* cell instance sky130_fd_sc_hd__fill_8_421 r0 *1 0,0
Xsky130_fd_sc_hd__fill_8_421 VSS VDD VDD sky130_fd_sc_hd__fill_8
* cell instance sky130_fd_sc_hd__fill_8_422 r0 *1 0,0
Xsky130_fd_sc_hd__fill_8_422 VSS VDD VDD sky130_fd_sc_hd__fill_8
* cell instance sky130_fd_sc_hd__fill_8_423 r0 *1 0,0
Xsky130_fd_sc_hd__fill_8_423 VSS VDD VDD sky130_fd_sc_hd__fill_8
* cell instance sky130_fd_sc_hd__fill_8_424 r0 *1 0,0
Xsky130_fd_sc_hd__fill_8_424 VSS VDD VDD sky130_fd_sc_hd__fill_8
* cell instance sky130_fd_sc_hd__fill_8_425 r0 *1 0,0
Xsky130_fd_sc_hd__fill_8_425 VSS VDD VDD sky130_fd_sc_hd__fill_8
* cell instance sky130_fd_sc_hd__fill_8_426 r0 *1 0,0
Xsky130_fd_sc_hd__fill_8_426 VSS VDD VDD sky130_fd_sc_hd__fill_8
* cell instance sky130_fd_sc_hd__fill_8_427 r0 *1 0,0
Xsky130_fd_sc_hd__fill_8_427 VSS VDD VDD sky130_fd_sc_hd__fill_8
* cell instance sky130_fd_sc_hd__fill_8_428 r0 *1 0,0
Xsky130_fd_sc_hd__fill_8_428 VSS VDD VDD sky130_fd_sc_hd__fill_8
* cell instance sky130_fd_sc_hd__fill_8_429 r0 *1 0,0
Xsky130_fd_sc_hd__fill_8_429 VSS VDD VDD sky130_fd_sc_hd__fill_8
* cell instance sky130_fd_sc_hd__fill_8_430 r0 *1 0,0
Xsky130_fd_sc_hd__fill_8_430 VSS VDD VDD sky130_fd_sc_hd__fill_8
* cell instance sky130_fd_sc_hd__fill_8_431 r0 *1 0,0
Xsky130_fd_sc_hd__fill_8_431 VSS VDD VDD sky130_fd_sc_hd__fill_8
* cell instance sky130_fd_sc_hd__fill_8_432 r0 *1 0,0
Xsky130_fd_sc_hd__fill_8_432 VSS VDD VDD sky130_fd_sc_hd__fill_8
* cell instance sky130_fd_sc_hd__fill_8_433 r0 *1 0,0
Xsky130_fd_sc_hd__fill_8_433 VSS VDD VDD sky130_fd_sc_hd__fill_8
* cell instance sky130_fd_sc_hd__fill_8_434 r0 *1 0,0
Xsky130_fd_sc_hd__fill_8_434 VSS VDD VDD sky130_fd_sc_hd__fill_8
* cell instance sky130_fd_sc_hd__fill_8_435 r0 *1 0,0
Xsky130_fd_sc_hd__fill_8_435 VSS VDD VDD sky130_fd_sc_hd__fill_8
* cell instance sky130_fd_sc_hd__fill_8_436 r0 *1 0,0
Xsky130_fd_sc_hd__fill_8_436 VSS VDD VDD sky130_fd_sc_hd__fill_8
* cell instance sky130_fd_sc_hd__fill_8_437 r0 *1 0,0
Xsky130_fd_sc_hd__fill_8_437 VSS VDD VDD sky130_fd_sc_hd__fill_8
* cell instance sky130_fd_sc_hd__fill_8_438 r0 *1 0,0
Xsky130_fd_sc_hd__fill_8_438 VSS VDD VDD sky130_fd_sc_hd__fill_8
* cell instance sky130_fd_sc_hd__fill_8_439 r0 *1 0,0
Xsky130_fd_sc_hd__fill_8_439 VSS VDD VDD sky130_fd_sc_hd__fill_8
* cell instance sky130_fd_sc_hd__fill_8_440 r0 *1 0,0
Xsky130_fd_sc_hd__fill_8_440 VSS VDD VDD sky130_fd_sc_hd__fill_8
* cell instance sky130_fd_sc_hd__fill_8_441 r0 *1 0,0
Xsky130_fd_sc_hd__fill_8_441 VSS VDD VDD sky130_fd_sc_hd__fill_8
* cell instance sky130_fd_sc_hd__fill_8_442 r0 *1 0,0
Xsky130_fd_sc_hd__fill_8_442 VSS VDD VDD sky130_fd_sc_hd__fill_8
* cell instance sky130_fd_sc_hd__fill_8_443 r0 *1 0,0
Xsky130_fd_sc_hd__fill_8_443 VSS VDD VDD sky130_fd_sc_hd__fill_8
* cell instance sky130_fd_sc_hd__fill_8_444 r0 *1 0,0
Xsky130_fd_sc_hd__fill_8_444 VSS VDD VDD sky130_fd_sc_hd__fill_8
* cell instance sky130_fd_sc_hd__fill_8_445 r0 *1 0,0
Xsky130_fd_sc_hd__fill_8_445 VSS VDD VDD sky130_fd_sc_hd__fill_8
* cell instance sky130_fd_sc_hd__fill_8_446 r0 *1 0,0
Xsky130_fd_sc_hd__fill_8_446 VSS VDD VDD sky130_fd_sc_hd__fill_8
* cell instance sky130_fd_sc_hd__fill_8_447 r0 *1 0,0
Xsky130_fd_sc_hd__fill_8_447 VSS VDD VDD sky130_fd_sc_hd__fill_8
* cell instance sky130_fd_sc_hd__fill_8_448 r0 *1 0,0
Xsky130_fd_sc_hd__fill_8_448 VSS VDD VDD sky130_fd_sc_hd__fill_8
* cell instance sky130_fd_sc_hd__fill_8_449 r0 *1 0,0
Xsky130_fd_sc_hd__fill_8_449 VSS VDD VDD sky130_fd_sc_hd__fill_8
* cell instance sky130_fd_sc_hd__fill_8_450 r0 *1 0,0
Xsky130_fd_sc_hd__fill_8_450 VSS VDD VDD sky130_fd_sc_hd__fill_8
* cell instance sky130_fd_sc_hd__fill_8_451 r0 *1 0,0
Xsky130_fd_sc_hd__fill_8_451 VSS VDD VDD sky130_fd_sc_hd__fill_8
* cell instance sky130_fd_sc_hd__fill_8_452 r0 *1 0,0
Xsky130_fd_sc_hd__fill_8_452 VSS VDD VDD sky130_fd_sc_hd__fill_8
* cell instance sky130_fd_sc_hd__fill_8_453 r0 *1 0,0
Xsky130_fd_sc_hd__fill_8_453 VSS VDD VDD sky130_fd_sc_hd__fill_8
* cell instance sky130_fd_sc_hd__fill_8_454 r0 *1 0,0
Xsky130_fd_sc_hd__fill_8_454 VSS VDD VDD sky130_fd_sc_hd__fill_8
* cell instance sky130_fd_sc_hd__fill_8_455 r0 *1 0,0
Xsky130_fd_sc_hd__fill_8_455 VSS VDD VDD sky130_fd_sc_hd__fill_8
* cell instance sky130_fd_sc_hd__fill_8_456 r0 *1 0,0
Xsky130_fd_sc_hd__fill_8_456 VSS VDD VDD sky130_fd_sc_hd__fill_8
* cell instance sky130_fd_sc_hd__fill_8_457 r0 *1 0,0
Xsky130_fd_sc_hd__fill_8_457 VSS VDD VDD sky130_fd_sc_hd__fill_8
* cell instance sky130_fd_sc_hd__fill_8_458 r0 *1 0,0
Xsky130_fd_sc_hd__fill_8_458 VSS VDD VDD sky130_fd_sc_hd__fill_8
* cell instance sky130_fd_sc_hd__fill_8_459 r0 *1 0,0
Xsky130_fd_sc_hd__fill_8_459 VSS VDD VDD sky130_fd_sc_hd__fill_8
* cell instance sky130_fd_sc_hd__fill_8_460 r0 *1 0,0
Xsky130_fd_sc_hd__fill_8_460 VSS VDD VDD sky130_fd_sc_hd__fill_8
* cell instance sky130_fd_sc_hd__fill_8_461 r0 *1 0,0
Xsky130_fd_sc_hd__fill_8_461 VSS VDD VDD sky130_fd_sc_hd__fill_8
* cell instance sky130_fd_sc_hd__fill_8_462 r0 *1 0,0
Xsky130_fd_sc_hd__fill_8_462 VSS VDD VDD sky130_fd_sc_hd__fill_8
* cell instance sky130_fd_sc_hd__fill_8_463 r0 *1 0,0
Xsky130_fd_sc_hd__fill_8_463 VSS VDD VDD sky130_fd_sc_hd__fill_8
* cell instance sky130_fd_sc_hd__fill_8_464 r0 *1 0,0
Xsky130_fd_sc_hd__fill_8_464 VSS VDD VDD sky130_fd_sc_hd__fill_8
* cell instance sky130_fd_sc_hd__fill_8_465 r0 *1 0,0
Xsky130_fd_sc_hd__fill_8_465 VSS VDD VDD sky130_fd_sc_hd__fill_8
* cell instance sky130_fd_sc_hd__fill_8_466 r0 *1 0,0
Xsky130_fd_sc_hd__fill_8_466 VSS VDD VDD sky130_fd_sc_hd__fill_8
* cell instance sky130_fd_sc_hd__fill_8_467 r0 *1 0,0
Xsky130_fd_sc_hd__fill_8_467 VSS VDD VDD sky130_fd_sc_hd__fill_8
* cell instance sky130_fd_sc_hd__fill_8_468 r0 *1 0,0
Xsky130_fd_sc_hd__fill_8_468 VSS VDD VDD sky130_fd_sc_hd__fill_8
* cell instance sky130_fd_sc_hd__fill_8_469 r0 *1 0,0
Xsky130_fd_sc_hd__fill_8_469 VSS VDD VDD sky130_fd_sc_hd__fill_8
* cell instance sky130_fd_sc_hd__fill_8_470 r0 *1 0,0
Xsky130_fd_sc_hd__fill_8_470 VSS VDD VDD sky130_fd_sc_hd__fill_8
* cell instance sky130_fd_sc_hd__fill_8_471 r0 *1 0,0
Xsky130_fd_sc_hd__fill_8_471 VSS VDD VDD sky130_fd_sc_hd__fill_8
* cell instance sky130_fd_sc_hd__fill_8_472 r0 *1 0,0
Xsky130_fd_sc_hd__fill_8_472 VSS VDD VDD sky130_fd_sc_hd__fill_8
* cell instance sky130_fd_sc_hd__fill_8_473 r0 *1 0,0
Xsky130_fd_sc_hd__fill_8_473 VSS VDD VDD sky130_fd_sc_hd__fill_8
* cell instance sky130_fd_sc_hd__fill_8_474 r0 *1 0,0
Xsky130_fd_sc_hd__fill_8_474 VSS VDD VDD sky130_fd_sc_hd__fill_8
* cell instance sky130_fd_sc_hd__fill_8_475 r0 *1 0,0
Xsky130_fd_sc_hd__fill_8_475 VSS VDD VDD sky130_fd_sc_hd__fill_8
* cell instance sky130_fd_sc_hd__fill_8_476 r0 *1 0,0
Xsky130_fd_sc_hd__fill_8_476 VSS VDD VDD sky130_fd_sc_hd__fill_8
* cell instance sky130_fd_sc_hd__fill_8_477 r0 *1 0,0
Xsky130_fd_sc_hd__fill_8_477 VSS VDD VDD sky130_fd_sc_hd__fill_8
* cell instance sky130_fd_sc_hd__fill_8_478 r0 *1 0,0
Xsky130_fd_sc_hd__fill_8_478 VSS VDD VDD sky130_fd_sc_hd__fill_8
* cell instance sky130_fd_sc_hd__fill_8_479 r0 *1 0,0
Xsky130_fd_sc_hd__fill_8_479 VSS VDD VDD sky130_fd_sc_hd__fill_8
* cell instance sky130_fd_sc_hd__fill_8_480 r0 *1 0,0
Xsky130_fd_sc_hd__fill_8_480 VSS VDD VDD sky130_fd_sc_hd__fill_8
* cell instance sky130_fd_sc_hd__fill_8_481 r0 *1 0,0
Xsky130_fd_sc_hd__fill_8_481 VSS VDD VDD sky130_fd_sc_hd__fill_8
* cell instance sky130_fd_sc_hd__fill_8_482 r0 *1 0,0
Xsky130_fd_sc_hd__fill_8_482 VSS VDD VDD sky130_fd_sc_hd__fill_8
* cell instance sky130_fd_sc_hd__fill_8_483 r0 *1 0,0
Xsky130_fd_sc_hd__fill_8_483 VSS VDD VDD sky130_fd_sc_hd__fill_8
* cell instance sky130_fd_sc_hd__fill_8_484 r0 *1 0,0
Xsky130_fd_sc_hd__fill_8_484 VSS VDD VDD sky130_fd_sc_hd__fill_8
* cell instance sky130_fd_sc_hd__fill_8_485 r0 *1 0,0
Xsky130_fd_sc_hd__fill_8_485 VSS VDD VDD sky130_fd_sc_hd__fill_8
* cell instance sky130_fd_sc_hd__fill_8_486 r0 *1 0,0
Xsky130_fd_sc_hd__fill_8_486 VSS VDD VDD sky130_fd_sc_hd__fill_8
* cell instance sky130_fd_sc_hd__fill_8_487 r0 *1 0,0
Xsky130_fd_sc_hd__fill_8_487 VSS VDD VDD sky130_fd_sc_hd__fill_8
* cell instance sky130_fd_sc_hd__fill_8_488 r0 *1 0,0
Xsky130_fd_sc_hd__fill_8_488 VSS VDD VDD sky130_fd_sc_hd__fill_8
* cell instance sky130_fd_sc_hd__fill_8_489 r0 *1 0,0
Xsky130_fd_sc_hd__fill_8_489 VSS VDD VDD sky130_fd_sc_hd__fill_8
* cell instance sky130_fd_sc_hd__fill_8_490 r0 *1 0,0
Xsky130_fd_sc_hd__fill_8_490 VSS VDD VDD sky130_fd_sc_hd__fill_8
* cell instance sky130_fd_sc_hd__fill_8_491 r0 *1 0,0
Xsky130_fd_sc_hd__fill_8_491 VSS VDD VDD sky130_fd_sc_hd__fill_8
* cell instance sky130_fd_sc_hd__fill_8_492 r0 *1 0,0
Xsky130_fd_sc_hd__fill_8_492 VSS VDD VDD sky130_fd_sc_hd__fill_8
* cell instance sky130_fd_sc_hd__fill_8_493 r0 *1 0,0
Xsky130_fd_sc_hd__fill_8_493 VSS VDD VDD sky130_fd_sc_hd__fill_8
* cell instance sky130_fd_sc_hd__fill_8_494 r0 *1 0,0
Xsky130_fd_sc_hd__fill_8_494 VSS VDD VDD sky130_fd_sc_hd__fill_8
* cell instance sky130_fd_sc_hd__fill_8_495 r0 *1 0,0
Xsky130_fd_sc_hd__fill_8_495 VSS VDD VDD sky130_fd_sc_hd__fill_8
* cell instance sky130_fd_sc_hd__fill_8_496 r0 *1 0,0
Xsky130_fd_sc_hd__fill_8_496 VSS VDD VDD sky130_fd_sc_hd__fill_8
* cell instance sky130_fd_sc_hd__fill_8_497 r0 *1 0,0
Xsky130_fd_sc_hd__fill_8_497 VSS VDD VDD sky130_fd_sc_hd__fill_8
* cell instance sky130_fd_sc_hd__fill_8_498 r0 *1 0,0
Xsky130_fd_sc_hd__fill_8_498 VSS VDD VDD sky130_fd_sc_hd__fill_8
* cell instance sky130_fd_sc_hd__fill_8_499 r0 *1 0,0
Xsky130_fd_sc_hd__fill_8_499 VSS VDD VDD sky130_fd_sc_hd__fill_8
* cell instance sky130_fd_sc_hd__fill_8_500 r0 *1 0,0
Xsky130_fd_sc_hd__fill_8_500 VSS VDD VDD sky130_fd_sc_hd__fill_8
* cell instance sky130_fd_sc_hd__fill_8_501 r0 *1 0,0
Xsky130_fd_sc_hd__fill_8_501 VSS VDD VDD sky130_fd_sc_hd__fill_8
* cell instance sky130_fd_sc_hd__fill_8_502 r0 *1 0,0
Xsky130_fd_sc_hd__fill_8_502 VSS VDD VDD sky130_fd_sc_hd__fill_8
* cell instance sky130_fd_sc_hd__fill_8_503 r0 *1 0,0
Xsky130_fd_sc_hd__fill_8_503 VSS VDD VDD sky130_fd_sc_hd__fill_8
* cell instance sky130_fd_sc_hd__fill_8_504 r0 *1 0,0
Xsky130_fd_sc_hd__fill_8_504 VSS VDD VDD sky130_fd_sc_hd__fill_8
* cell instance sky130_fd_sc_hd__fill_8_505 r0 *1 0,0
Xsky130_fd_sc_hd__fill_8_505 VSS VDD VDD sky130_fd_sc_hd__fill_8
* cell instance sky130_fd_sc_hd__fill_8_506 r0 *1 0,0
Xsky130_fd_sc_hd__fill_8_506 VSS VDD VDD sky130_fd_sc_hd__fill_8
* cell instance sky130_fd_sc_hd__fill_8_507 r0 *1 0,0
Xsky130_fd_sc_hd__fill_8_507 VSS VDD VDD sky130_fd_sc_hd__fill_8
* cell instance sky130_fd_sc_hd__fill_8_508 r0 *1 0,0
Xsky130_fd_sc_hd__fill_8_508 VSS VDD VDD sky130_fd_sc_hd__fill_8
* cell instance sky130_fd_sc_hd__fill_8_509 r0 *1 0,0
Xsky130_fd_sc_hd__fill_8_509 VSS VDD VDD sky130_fd_sc_hd__fill_8
* cell instance sky130_fd_sc_hd__fill_8_510 r0 *1 0,0
Xsky130_fd_sc_hd__fill_8_510 VSS VDD VDD sky130_fd_sc_hd__fill_8
* cell instance sky130_fd_sc_hd__fill_8_511 r0 *1 0,0
Xsky130_fd_sc_hd__fill_8_511 VSS VDD VDD sky130_fd_sc_hd__fill_8
* cell instance sky130_fd_sc_hd__fill_8_512 r0 *1 0,0
Xsky130_fd_sc_hd__fill_8_512 VSS VDD VDD sky130_fd_sc_hd__fill_8
* cell instance sky130_fd_sc_hd__fill_8_513 r0 *1 0,0
Xsky130_fd_sc_hd__fill_8_513 VSS VDD VDD sky130_fd_sc_hd__fill_8
* cell instance sky130_fd_sc_hd__fill_8_514 r0 *1 0,0
Xsky130_fd_sc_hd__fill_8_514 VSS VDD VDD sky130_fd_sc_hd__fill_8
* cell instance sky130_fd_sc_hd__fill_8_515 r0 *1 0,0
Xsky130_fd_sc_hd__fill_8_515 VSS VDD VDD sky130_fd_sc_hd__fill_8
* cell instance sky130_fd_sc_hd__fill_8_516 r0 *1 0,0
Xsky130_fd_sc_hd__fill_8_516 VSS VDD VDD sky130_fd_sc_hd__fill_8
* cell instance sky130_fd_sc_hd__fill_8_517 r0 *1 0,0
Xsky130_fd_sc_hd__fill_8_517 VSS VDD VDD sky130_fd_sc_hd__fill_8
* cell instance sky130_fd_sc_hd__fill_8_518 r0 *1 0,0
Xsky130_fd_sc_hd__fill_8_518 VSS VDD VDD sky130_fd_sc_hd__fill_8
* cell instance sky130_fd_sc_hd__fill_8_519 r0 *1 0,0
Xsky130_fd_sc_hd__fill_8_519 VSS VDD VDD sky130_fd_sc_hd__fill_8
* cell instance sky130_fd_sc_hd__fill_8_520 r0 *1 0,0
Xsky130_fd_sc_hd__fill_8_520 VSS VDD VDD sky130_fd_sc_hd__fill_8
* cell instance sky130_fd_sc_hd__fill_8_521 r0 *1 0,0
Xsky130_fd_sc_hd__fill_8_521 VSS VDD VDD sky130_fd_sc_hd__fill_8
* cell instance sky130_fd_sc_hd__fill_8_522 r0 *1 0,0
Xsky130_fd_sc_hd__fill_8_522 VSS VDD VDD sky130_fd_sc_hd__fill_8
* cell instance sky130_fd_sc_hd__fill_8_523 r0 *1 0,0
Xsky130_fd_sc_hd__fill_8_523 VSS VDD VDD sky130_fd_sc_hd__fill_8
* cell instance sky130_fd_sc_hd__fill_8_524 r0 *1 0,0
Xsky130_fd_sc_hd__fill_8_524 VSS VDD VDD sky130_fd_sc_hd__fill_8
* cell instance sky130_fd_sc_hd__fill_8_525 r0 *1 0,0
Xsky130_fd_sc_hd__fill_8_525 VSS VDD VDD sky130_fd_sc_hd__fill_8
* cell instance sky130_fd_sc_hd__fill_8_526 r0 *1 0,0
Xsky130_fd_sc_hd__fill_8_526 VSS VDD VDD sky130_fd_sc_hd__fill_8
* cell instance sky130_fd_sc_hd__fill_8_527 r0 *1 0,0
Xsky130_fd_sc_hd__fill_8_527 VSS VDD VDD sky130_fd_sc_hd__fill_8
* cell instance sky130_fd_sc_hd__fill_8_528 r0 *1 0,0
Xsky130_fd_sc_hd__fill_8_528 VSS VDD VDD sky130_fd_sc_hd__fill_8
* cell instance sky130_fd_sc_hd__fill_8_529 r0 *1 0,0
Xsky130_fd_sc_hd__fill_8_529 VSS VDD VDD sky130_fd_sc_hd__fill_8
* cell instance sky130_fd_sc_hd__fill_8_530 r0 *1 0,0
Xsky130_fd_sc_hd__fill_8_530 VSS VDD VDD sky130_fd_sc_hd__fill_8
* cell instance sky130_fd_sc_hd__fill_8_531 r0 *1 0,0
Xsky130_fd_sc_hd__fill_8_531 VSS VDD VDD sky130_fd_sc_hd__fill_8
* cell instance sky130_fd_sc_hd__fill_8_532 r0 *1 0,0
Xsky130_fd_sc_hd__fill_8_532 VSS VDD VDD sky130_fd_sc_hd__fill_8
* cell instance sky130_fd_sc_hd__fill_8_533 r0 *1 0,0
Xsky130_fd_sc_hd__fill_8_533 VSS VDD VDD sky130_fd_sc_hd__fill_8
* cell instance sky130_fd_sc_hd__fill_8_534 r0 *1 0,0
Xsky130_fd_sc_hd__fill_8_534 VSS VDD VDD sky130_fd_sc_hd__fill_8
* cell instance sky130_fd_sc_hd__fill_8_535 r0 *1 0,0
Xsky130_fd_sc_hd__fill_8_535 VSS VDD VDD sky130_fd_sc_hd__fill_8
* cell instance sky130_fd_sc_hd__fill_8_536 r0 *1 0,0
Xsky130_fd_sc_hd__fill_8_536 VSS VDD VDD sky130_fd_sc_hd__fill_8
* cell instance sky130_fd_sc_hd__fill_8_537 r0 *1 0,0
Xsky130_fd_sc_hd__fill_8_537 VSS VDD VDD sky130_fd_sc_hd__fill_8
* cell instance sky130_fd_sc_hd__fill_8_538 r0 *1 0,0
Xsky130_fd_sc_hd__fill_8_538 VSS VDD VDD sky130_fd_sc_hd__fill_8
* cell instance sky130_fd_sc_hd__fill_8_539 r0 *1 0,0
Xsky130_fd_sc_hd__fill_8_539 VSS VDD VDD sky130_fd_sc_hd__fill_8
* cell instance sky130_fd_sc_hd__fill_8_540 r0 *1 0,0
Xsky130_fd_sc_hd__fill_8_540 VSS VDD VDD sky130_fd_sc_hd__fill_8
* cell instance sky130_fd_sc_hd__fill_8_541 r0 *1 0,0
Xsky130_fd_sc_hd__fill_8_541 VSS VDD VDD sky130_fd_sc_hd__fill_8
* cell instance sky130_fd_sc_hd__fill_8_542 r0 *1 0,0
Xsky130_fd_sc_hd__fill_8_542 VSS VDD VDD sky130_fd_sc_hd__fill_8
* cell instance sky130_fd_sc_hd__fill_8_543 r0 *1 0,0
Xsky130_fd_sc_hd__fill_8_543 VSS VDD VDD sky130_fd_sc_hd__fill_8
* cell instance sky130_fd_sc_hd__fill_8_544 r0 *1 0,0
Xsky130_fd_sc_hd__fill_8_544 VSS VDD VDD sky130_fd_sc_hd__fill_8
* cell instance sky130_fd_sc_hd__fill_8_545 r0 *1 0,0
Xsky130_fd_sc_hd__fill_8_545 VSS VDD VDD sky130_fd_sc_hd__fill_8
* cell instance sky130_fd_sc_hd__fill_8_546 r0 *1 0,0
Xsky130_fd_sc_hd__fill_8_546 VSS VDD VDD sky130_fd_sc_hd__fill_8
* cell instance sky130_fd_sc_hd__fill_8_547 r0 *1 0,0
Xsky130_fd_sc_hd__fill_8_547 VSS VDD VDD sky130_fd_sc_hd__fill_8
* cell instance sky130_fd_sc_hd__fill_8_548 r0 *1 0,0
Xsky130_fd_sc_hd__fill_8_548 VSS VDD VDD sky130_fd_sc_hd__fill_8
* cell instance sky130_fd_sc_hd__fill_8_549 r0 *1 0,0
Xsky130_fd_sc_hd__fill_8_549 VSS VDD VDD sky130_fd_sc_hd__fill_8
* cell instance sky130_fd_sc_hd__fill_8_550 r0 *1 0,0
Xsky130_fd_sc_hd__fill_8_550 VSS VDD VDD sky130_fd_sc_hd__fill_8
* cell instance sky130_fd_sc_hd__fill_8_551 r0 *1 0,0
Xsky130_fd_sc_hd__fill_8_551 VSS VDD VDD sky130_fd_sc_hd__fill_8
* cell instance sky130_fd_sc_hd__fill_8_552 r0 *1 0,0
Xsky130_fd_sc_hd__fill_8_552 VSS VDD VDD sky130_fd_sc_hd__fill_8
* cell instance sky130_fd_sc_hd__fill_8_553 r0 *1 0,0
Xsky130_fd_sc_hd__fill_8_553 VSS VDD VDD sky130_fd_sc_hd__fill_8
* cell instance sky130_fd_sc_hd__fill_8_554 r0 *1 0,0
Xsky130_fd_sc_hd__fill_8_554 VSS VDD VDD sky130_fd_sc_hd__fill_8
* cell instance sky130_fd_sc_hd__fill_8_555 r0 *1 0,0
Xsky130_fd_sc_hd__fill_8_555 VSS VDD VDD sky130_fd_sc_hd__fill_8
* cell instance sky130_fd_sc_hd__fill_8_556 r0 *1 0,0
Xsky130_fd_sc_hd__fill_8_556 VSS VDD VDD sky130_fd_sc_hd__fill_8
* cell instance sky130_fd_sc_hd__fill_8_557 r0 *1 0,0
Xsky130_fd_sc_hd__fill_8_557 VSS VDD VDD sky130_fd_sc_hd__fill_8
* cell instance sky130_fd_sc_hd__fill_8_558 r0 *1 0,0
Xsky130_fd_sc_hd__fill_8_558 VSS VDD VDD sky130_fd_sc_hd__fill_8
* cell instance sky130_fd_sc_hd__fill_8_559 r0 *1 0,0
Xsky130_fd_sc_hd__fill_8_559 VSS VDD VDD sky130_fd_sc_hd__fill_8
* cell instance sky130_fd_sc_hd__fill_8_560 r0 *1 0,0
Xsky130_fd_sc_hd__fill_8_560 VSS VDD VDD sky130_fd_sc_hd__fill_8
* cell instance sky130_fd_sc_hd__fill_8_561 r0 *1 0,0
Xsky130_fd_sc_hd__fill_8_561 VSS VDD VDD sky130_fd_sc_hd__fill_8
* cell instance sky130_fd_sc_hd__fill_8_562 r0 *1 0,0
Xsky130_fd_sc_hd__fill_8_562 VSS VDD VDD sky130_fd_sc_hd__fill_8
* cell instance sky130_fd_sc_hd__fill_8_563 r0 *1 0,0
Xsky130_fd_sc_hd__fill_8_563 VSS VDD VDD sky130_fd_sc_hd__fill_8
* cell instance sky130_fd_sc_hd__fill_8_564 r0 *1 0,0
Xsky130_fd_sc_hd__fill_8_564 VSS VDD VDD sky130_fd_sc_hd__fill_8
* cell instance sky130_fd_sc_hd__fill_8_565 r0 *1 0,0
Xsky130_fd_sc_hd__fill_8_565 VSS VDD VDD sky130_fd_sc_hd__fill_8
* cell instance sky130_fd_sc_hd__fill_8_566 r0 *1 0,0
Xsky130_fd_sc_hd__fill_8_566 VSS VDD VDD sky130_fd_sc_hd__fill_8
* cell instance sky130_fd_sc_hd__fill_8_567 r0 *1 0,0
Xsky130_fd_sc_hd__fill_8_567 VSS VDD VDD sky130_fd_sc_hd__fill_8
* cell instance sky130_fd_sc_hd__fill_8_568 r0 *1 0,0
Xsky130_fd_sc_hd__fill_8_568 VSS VDD VDD sky130_fd_sc_hd__fill_8
* cell instance sky130_fd_sc_hd__fill_8_569 r0 *1 0,0
Xsky130_fd_sc_hd__fill_8_569 VSS VDD VDD sky130_fd_sc_hd__fill_8
* cell instance sky130_fd_sc_hd__fill_8_570 r0 *1 0,0
Xsky130_fd_sc_hd__fill_8_570 VSS VDD VDD sky130_fd_sc_hd__fill_8
* cell instance sky130_fd_sc_hd__fill_8_571 r0 *1 0,0
Xsky130_fd_sc_hd__fill_8_571 VSS VDD VDD sky130_fd_sc_hd__fill_8
* cell instance sky130_fd_sc_hd__fill_8_572 r0 *1 0,0
Xsky130_fd_sc_hd__fill_8_572 VSS VDD VDD sky130_fd_sc_hd__fill_8
* cell instance sky130_fd_sc_hd__fill_8_573 r0 *1 0,0
Xsky130_fd_sc_hd__fill_8_573 VSS VDD VDD sky130_fd_sc_hd__fill_8
* cell instance sky130_fd_sc_hd__fill_8_574 r0 *1 0,0
Xsky130_fd_sc_hd__fill_8_574 VSS VDD VDD sky130_fd_sc_hd__fill_8
* cell instance sky130_fd_sc_hd__fill_8_575 r0 *1 0,0
Xsky130_fd_sc_hd__fill_8_575 VSS VDD VDD sky130_fd_sc_hd__fill_8
* cell instance sky130_fd_sc_hd__fill_8_576 r0 *1 0,0
Xsky130_fd_sc_hd__fill_8_576 VSS VDD VDD sky130_fd_sc_hd__fill_8
* cell instance sky130_fd_sc_hd__fill_8_577 r0 *1 0,0
Xsky130_fd_sc_hd__fill_8_577 VSS VDD VDD sky130_fd_sc_hd__fill_8
* cell instance sky130_fd_sc_hd__fill_8_578 r0 *1 0,0
Xsky130_fd_sc_hd__fill_8_578 VSS VDD VDD sky130_fd_sc_hd__fill_8
* cell instance sky130_fd_sc_hd__fill_8_579 r0 *1 0,0
Xsky130_fd_sc_hd__fill_8_579 VSS VDD VDD sky130_fd_sc_hd__fill_8
* cell instance sky130_fd_sc_hd__fill_8_580 r0 *1 0,0
Xsky130_fd_sc_hd__fill_8_580 VSS VDD VDD sky130_fd_sc_hd__fill_8
* cell instance sky130_fd_sc_hd__fill_8_581 r0 *1 0,0
Xsky130_fd_sc_hd__fill_8_581 VSS VDD VDD sky130_fd_sc_hd__fill_8
* cell instance sky130_fd_sc_hd__fill_8_582 r0 *1 0,0
Xsky130_fd_sc_hd__fill_8_582 VSS VDD VDD sky130_fd_sc_hd__fill_8
* cell instance sky130_fd_sc_hd__fill_8_583 r0 *1 0,0
Xsky130_fd_sc_hd__fill_8_583 VSS VDD VDD sky130_fd_sc_hd__fill_8
* cell instance sky130_fd_sc_hd__fill_8_584 r0 *1 0,0
Xsky130_fd_sc_hd__fill_8_584 VSS VDD VDD sky130_fd_sc_hd__fill_8
* cell instance sky130_fd_sc_hd__fill_8_585 r0 *1 0,0
Xsky130_fd_sc_hd__fill_8_585 VSS VDD VDD sky130_fd_sc_hd__fill_8
* cell instance sky130_fd_sc_hd__fill_8_586 r0 *1 0,0
Xsky130_fd_sc_hd__fill_8_586 VSS VDD VDD sky130_fd_sc_hd__fill_8
* cell instance sky130_fd_sc_hd__fill_8_587 r0 *1 0,0
Xsky130_fd_sc_hd__fill_8_587 VSS VDD VDD sky130_fd_sc_hd__fill_8
* cell instance sky130_fd_sc_hd__fill_8_588 r0 *1 0,0
Xsky130_fd_sc_hd__fill_8_588 VSS VDD VDD sky130_fd_sc_hd__fill_8
* cell instance sky130_fd_sc_hd__fill_8_589 r0 *1 0,0
Xsky130_fd_sc_hd__fill_8_589 VSS VDD VDD sky130_fd_sc_hd__fill_8
* cell instance sky130_fd_sc_hd__fill_8_590 r0 *1 0,0
Xsky130_fd_sc_hd__fill_8_590 VSS VDD VDD sky130_fd_sc_hd__fill_8
* cell instance sky130_fd_sc_hd__fill_8_591 r0 *1 0,0
Xsky130_fd_sc_hd__fill_8_591 VSS VDD VDD sky130_fd_sc_hd__fill_8
* cell instance sky130_fd_sc_hd__fill_8_592 r0 *1 0,0
Xsky130_fd_sc_hd__fill_8_592 VSS VDD VDD sky130_fd_sc_hd__fill_8
* cell instance sky130_fd_sc_hd__fill_8_593 r0 *1 0,0
Xsky130_fd_sc_hd__fill_8_593 VSS VDD VDD sky130_fd_sc_hd__fill_8
* cell instance sky130_fd_sc_hd__fill_8_594 r0 *1 0,0
Xsky130_fd_sc_hd__fill_8_594 VSS VDD VDD sky130_fd_sc_hd__fill_8
* cell instance sky130_fd_sc_hd__fill_8_595 r0 *1 0,0
Xsky130_fd_sc_hd__fill_8_595 VSS VDD VDD sky130_fd_sc_hd__fill_8
* cell instance sky130_fd_sc_hd__fill_8_596 r0 *1 0,0
Xsky130_fd_sc_hd__fill_8_596 VSS VDD VDD sky130_fd_sc_hd__fill_8
* cell instance sky130_fd_sc_hd__fill_8_597 r0 *1 0,0
Xsky130_fd_sc_hd__fill_8_597 VSS VDD VDD sky130_fd_sc_hd__fill_8
* cell instance sky130_fd_sc_hd__fill_8_598 r0 *1 0,0
Xsky130_fd_sc_hd__fill_8_598 VSS VDD VDD sky130_fd_sc_hd__fill_8
* cell instance sky130_fd_sc_hd__fill_8_599 r0 *1 0,0
Xsky130_fd_sc_hd__fill_8_599 VSS VDD VDD sky130_fd_sc_hd__fill_8
* cell instance sky130_fd_sc_hd__fill_8_600 r0 *1 0,0
Xsky130_fd_sc_hd__fill_8_600 VSS VDD VDD sky130_fd_sc_hd__fill_8
* cell instance sky130_fd_sc_hd__fill_8_601 r0 *1 0,0
Xsky130_fd_sc_hd__fill_8_601 VSS VDD VDD sky130_fd_sc_hd__fill_8
* cell instance sky130_fd_sc_hd__fill_8_602 r0 *1 0,0
Xsky130_fd_sc_hd__fill_8_602 VSS VDD VDD sky130_fd_sc_hd__fill_8
* cell instance sky130_fd_sc_hd__fill_8_603 r0 *1 0,0
Xsky130_fd_sc_hd__fill_8_603 VSS VDD VDD sky130_fd_sc_hd__fill_8
* cell instance sky130_fd_sc_hd__fill_8_604 r0 *1 0,0
Xsky130_fd_sc_hd__fill_8_604 VSS VDD VDD sky130_fd_sc_hd__fill_8
* cell instance sky130_fd_sc_hd__fill_8_605 r0 *1 0,0
Xsky130_fd_sc_hd__fill_8_605 VSS VDD VDD sky130_fd_sc_hd__fill_8
* cell instance sky130_fd_sc_hd__fill_8_606 r0 *1 0,0
Xsky130_fd_sc_hd__fill_8_606 VSS VDD VDD sky130_fd_sc_hd__fill_8
* cell instance sky130_fd_sc_hd__fill_8_607 r0 *1 0,0
Xsky130_fd_sc_hd__fill_8_607 VSS VDD VDD sky130_fd_sc_hd__fill_8
* cell instance sky130_fd_sc_hd__fill_8_608 r0 *1 0,0
Xsky130_fd_sc_hd__fill_8_608 VSS VDD VDD sky130_fd_sc_hd__fill_8
* cell instance sky130_fd_sc_hd__fill_8_609 r0 *1 0,0
Xsky130_fd_sc_hd__fill_8_609 VSS VDD VDD sky130_fd_sc_hd__fill_8
* cell instance sky130_fd_sc_hd__fill_8_610 r0 *1 0,0
Xsky130_fd_sc_hd__fill_8_610 VSS VDD VDD sky130_fd_sc_hd__fill_8
* cell instance sky130_fd_sc_hd__fill_8_611 r0 *1 0,0
Xsky130_fd_sc_hd__fill_8_611 VSS VDD VDD sky130_fd_sc_hd__fill_8
* cell instance sky130_fd_sc_hd__fill_8_612 r0 *1 0,0
Xsky130_fd_sc_hd__fill_8_612 VSS VDD VDD sky130_fd_sc_hd__fill_8
* cell instance sky130_fd_sc_hd__fill_8_613 r0 *1 0,0
Xsky130_fd_sc_hd__fill_8_613 VSS VDD VDD sky130_fd_sc_hd__fill_8
* cell instance sky130_fd_sc_hd__fill_8_614 r0 *1 0,0
Xsky130_fd_sc_hd__fill_8_614 VSS VDD VDD sky130_fd_sc_hd__fill_8
* cell instance sky130_fd_sc_hd__fill_8_615 r0 *1 0,0
Xsky130_fd_sc_hd__fill_8_615 VSS VDD VDD sky130_fd_sc_hd__fill_8
* cell instance sky130_fd_sc_hd__fill_8_616 r0 *1 0,0
Xsky130_fd_sc_hd__fill_8_616 VSS VDD VDD sky130_fd_sc_hd__fill_8
* cell instance sky130_fd_sc_hd__fill_8_617 r0 *1 0,0
Xsky130_fd_sc_hd__fill_8_617 VSS VDD VDD sky130_fd_sc_hd__fill_8
* cell instance sky130_fd_sc_hd__fill_8_618 r0 *1 0,0
Xsky130_fd_sc_hd__fill_8_618 VSS VDD VDD sky130_fd_sc_hd__fill_8
* cell instance sky130_fd_sc_hd__fill_8_619 r0 *1 0,0
Xsky130_fd_sc_hd__fill_8_619 VSS VDD VDD sky130_fd_sc_hd__fill_8
* cell instance sky130_fd_sc_hd__fill_8_620 r0 *1 0,0
Xsky130_fd_sc_hd__fill_8_620 VSS VDD VDD sky130_fd_sc_hd__fill_8
* cell instance sky130_fd_sc_hd__fill_8_621 r0 *1 0,0
Xsky130_fd_sc_hd__fill_8_621 VSS VDD VDD sky130_fd_sc_hd__fill_8
* cell instance sky130_fd_sc_hd__fill_8_622 r0 *1 0,0
Xsky130_fd_sc_hd__fill_8_622 VSS VDD VDD sky130_fd_sc_hd__fill_8
* cell instance sky130_fd_sc_hd__fill_8_623 r0 *1 0,0
Xsky130_fd_sc_hd__fill_8_623 VSS VDD VDD sky130_fd_sc_hd__fill_8
* cell instance sky130_fd_sc_hd__fill_8_624 r0 *1 0,0
Xsky130_fd_sc_hd__fill_8_624 VSS VDD VDD sky130_fd_sc_hd__fill_8
* cell instance sky130_fd_sc_hd__fill_8_625 r0 *1 0,0
Xsky130_fd_sc_hd__fill_8_625 VSS VDD VDD sky130_fd_sc_hd__fill_8
* cell instance sky130_fd_sc_hd__fill_8_626 r0 *1 0,0
Xsky130_fd_sc_hd__fill_8_626 VSS VDD VDD sky130_fd_sc_hd__fill_8
* cell instance sky130_fd_sc_hd__fill_8_627 r0 *1 0,0
Xsky130_fd_sc_hd__fill_8_627 VSS VDD VDD sky130_fd_sc_hd__fill_8
* cell instance sky130_fd_sc_hd__fill_8_628 r0 *1 0,0
Xsky130_fd_sc_hd__fill_8_628 VSS VDD VDD sky130_fd_sc_hd__fill_8
* cell instance sky130_fd_sc_hd__fill_8_629 r0 *1 0,0
Xsky130_fd_sc_hd__fill_8_629 VSS VDD VDD sky130_fd_sc_hd__fill_8
* cell instance sky130_fd_sc_hd__fill_8_630 r0 *1 0,0
Xsky130_fd_sc_hd__fill_8_630 VSS VDD VDD sky130_fd_sc_hd__fill_8
* cell instance sky130_fd_sc_hd__fill_8_631 r0 *1 0,0
Xsky130_fd_sc_hd__fill_8_631 VSS VDD VDD sky130_fd_sc_hd__fill_8
* cell instance sky130_fd_sc_hd__fill_8_632 r0 *1 0,0
Xsky130_fd_sc_hd__fill_8_632 VSS VDD VDD sky130_fd_sc_hd__fill_8
* cell instance sky130_fd_sc_hd__fill_8_633 r0 *1 0,0
Xsky130_fd_sc_hd__fill_8_633 VSS VDD VDD sky130_fd_sc_hd__fill_8
* cell instance sky130_fd_sc_hd__fill_8_634 r0 *1 0,0
Xsky130_fd_sc_hd__fill_8_634 VSS VDD VDD sky130_fd_sc_hd__fill_8
* cell instance sky130_fd_sc_hd__fill_8_635 r0 *1 0,0
Xsky130_fd_sc_hd__fill_8_635 VSS VDD VDD sky130_fd_sc_hd__fill_8
* cell instance sky130_fd_sc_hd__fill_8_636 r0 *1 0,0
Xsky130_fd_sc_hd__fill_8_636 VSS VDD VDD sky130_fd_sc_hd__fill_8
* cell instance sky130_fd_sc_hd__fill_8_637 r0 *1 0,0
Xsky130_fd_sc_hd__fill_8_637 VSS VDD VDD sky130_fd_sc_hd__fill_8
* cell instance sky130_fd_sc_hd__fill_8_638 r0 *1 0,0
Xsky130_fd_sc_hd__fill_8_638 VSS VDD VDD sky130_fd_sc_hd__fill_8
* cell instance sky130_fd_sc_hd__fill_8_639 r0 *1 0,0
Xsky130_fd_sc_hd__fill_8_639 VSS VDD VDD sky130_fd_sc_hd__fill_8
* cell instance sky130_fd_sc_hd__fill_8_640 r0 *1 0,0
Xsky130_fd_sc_hd__fill_8_640 VSS VDD VDD sky130_fd_sc_hd__fill_8
* cell instance sky130_fd_sc_hd__fill_8_641 r0 *1 0,0
Xsky130_fd_sc_hd__fill_8_641 VSS VDD VDD sky130_fd_sc_hd__fill_8
* cell instance sky130_fd_sc_hd__fill_8_642 r0 *1 0,0
Xsky130_fd_sc_hd__fill_8_642 VSS VDD VDD sky130_fd_sc_hd__fill_8
* cell instance sky130_fd_sc_hd__fill_8_643 r0 *1 0,0
Xsky130_fd_sc_hd__fill_8_643 VSS VDD VDD sky130_fd_sc_hd__fill_8
* cell instance sky130_fd_sc_hd__fill_8_644 r0 *1 0,0
Xsky130_fd_sc_hd__fill_8_644 VSS VDD VDD sky130_fd_sc_hd__fill_8
* cell instance sky130_fd_sc_hd__fill_8_645 r0 *1 0,0
Xsky130_fd_sc_hd__fill_8_645 VSS VDD VDD sky130_fd_sc_hd__fill_8
* cell instance sky130_fd_sc_hd__fill_8_646 r0 *1 0,0
Xsky130_fd_sc_hd__fill_8_646 VSS VDD VDD sky130_fd_sc_hd__fill_8
* cell instance sky130_fd_sc_hd__fill_8_647 r0 *1 0,0
Xsky130_fd_sc_hd__fill_8_647 VSS VDD VDD sky130_fd_sc_hd__fill_8
* cell instance sky130_fd_sc_hd__fill_8_648 r0 *1 0,0
Xsky130_fd_sc_hd__fill_8_648 VSS VDD VDD sky130_fd_sc_hd__fill_8
* cell instance sky130_fd_sc_hd__fill_8_649 r0 *1 0,0
Xsky130_fd_sc_hd__fill_8_649 VSS VDD VDD sky130_fd_sc_hd__fill_8
* cell instance sky130_fd_sc_hd__fill_8_650 r0 *1 0,0
Xsky130_fd_sc_hd__fill_8_650 VSS VDD VDD sky130_fd_sc_hd__fill_8
* cell instance sky130_fd_sc_hd__fill_8_651 r0 *1 0,0
Xsky130_fd_sc_hd__fill_8_651 VSS VDD VDD sky130_fd_sc_hd__fill_8
* cell instance sky130_fd_sc_hd__fill_8_652 r0 *1 0,0
Xsky130_fd_sc_hd__fill_8_652 VSS VDD VDD sky130_fd_sc_hd__fill_8
* cell instance sky130_fd_sc_hd__fill_8_653 r0 *1 0,0
Xsky130_fd_sc_hd__fill_8_653 VSS VDD VDD sky130_fd_sc_hd__fill_8
* cell instance sky130_fd_sc_hd__fill_8_654 r0 *1 0,0
Xsky130_fd_sc_hd__fill_8_654 VSS VDD VDD sky130_fd_sc_hd__fill_8
* cell instance sky130_fd_sc_hd__fill_8_655 r0 *1 0,0
Xsky130_fd_sc_hd__fill_8_655 VSS VDD VDD sky130_fd_sc_hd__fill_8
* cell instance sky130_fd_sc_hd__fill_8_656 r0 *1 0,0
Xsky130_fd_sc_hd__fill_8_656 VSS VDD VDD sky130_fd_sc_hd__fill_8
* cell instance sky130_fd_sc_hd__fill_8_657 r0 *1 0,0
Xsky130_fd_sc_hd__fill_8_657 VSS VDD VDD sky130_fd_sc_hd__fill_8
* cell instance sky130_fd_sc_hd__fill_8_658 r0 *1 0,0
Xsky130_fd_sc_hd__fill_8_658 VSS VDD VDD sky130_fd_sc_hd__fill_8
* cell instance sky130_fd_sc_hd__fill_8_659 r0 *1 0,0
Xsky130_fd_sc_hd__fill_8_659 VSS VDD VDD sky130_fd_sc_hd__fill_8
* cell instance sky130_fd_sc_hd__fill_8_660 r0 *1 0,0
Xsky130_fd_sc_hd__fill_8_660 VSS VDD VDD sky130_fd_sc_hd__fill_8
* cell instance sky130_fd_sc_hd__fill_8_661 r0 *1 0,0
Xsky130_fd_sc_hd__fill_8_661 VSS VDD VDD sky130_fd_sc_hd__fill_8
* cell instance sky130_fd_sc_hd__fill_8_662 r0 *1 0,0
Xsky130_fd_sc_hd__fill_8_662 VSS VDD VDD sky130_fd_sc_hd__fill_8
* cell instance sky130_fd_sc_hd__fill_8_663 r0 *1 0,0
Xsky130_fd_sc_hd__fill_8_663 VSS VDD VDD sky130_fd_sc_hd__fill_8
* cell instance sky130_fd_sc_hd__fill_8_664 r0 *1 0,0
Xsky130_fd_sc_hd__fill_8_664 VSS VDD VDD sky130_fd_sc_hd__fill_8
* cell instance sky130_fd_sc_hd__fill_8_665 r0 *1 0,0
Xsky130_fd_sc_hd__fill_8_665 VSS VDD VDD sky130_fd_sc_hd__fill_8
* cell instance sky130_fd_sc_hd__fill_8_666 r0 *1 0,0
Xsky130_fd_sc_hd__fill_8_666 VSS VDD VDD sky130_fd_sc_hd__fill_8
* cell instance sky130_fd_sc_hd__fill_8_667 r0 *1 0,0
Xsky130_fd_sc_hd__fill_8_667 VSS VDD VDD sky130_fd_sc_hd__fill_8
* cell instance sky130_fd_sc_hd__fill_8_668 r0 *1 0,0
Xsky130_fd_sc_hd__fill_8_668 VSS VDD VDD sky130_fd_sc_hd__fill_8
* cell instance sky130_fd_sc_hd__fill_8_669 r0 *1 0,0
Xsky130_fd_sc_hd__fill_8_669 VSS VDD VDD sky130_fd_sc_hd__fill_8
* cell instance sky130_fd_sc_hd__fill_8_670 r0 *1 0,0
Xsky130_fd_sc_hd__fill_8_670 VSS VDD VDD sky130_fd_sc_hd__fill_8
* cell instance sky130_fd_sc_hd__fill_8_671 r0 *1 0,0
Xsky130_fd_sc_hd__fill_8_671 VSS VDD VDD sky130_fd_sc_hd__fill_8
* cell instance sky130_fd_sc_hd__fill_8_672 r0 *1 0,0
Xsky130_fd_sc_hd__fill_8_672 VSS VDD VDD sky130_fd_sc_hd__fill_8
* cell instance sky130_fd_sc_hd__fill_8_673 r0 *1 0,0
Xsky130_fd_sc_hd__fill_8_673 VSS VDD VDD sky130_fd_sc_hd__fill_8
* cell instance sky130_fd_sc_hd__fill_8_674 r0 *1 0,0
Xsky130_fd_sc_hd__fill_8_674 VSS VDD VDD sky130_fd_sc_hd__fill_8
* cell instance sky130_fd_sc_hd__fill_8_675 r0 *1 0,0
Xsky130_fd_sc_hd__fill_8_675 VSS VDD VDD sky130_fd_sc_hd__fill_8
* cell instance sky130_fd_sc_hd__fill_8_676 r0 *1 0,0
Xsky130_fd_sc_hd__fill_8_676 VSS VDD VDD sky130_fd_sc_hd__fill_8
* cell instance sky130_fd_sc_hd__fill_8_677 r0 *1 0,0
Xsky130_fd_sc_hd__fill_8_677 VSS VDD VDD sky130_fd_sc_hd__fill_8
* cell instance sky130_fd_sc_hd__fill_8_678 r0 *1 0,0
Xsky130_fd_sc_hd__fill_8_678 VSS VDD VDD sky130_fd_sc_hd__fill_8
* cell instance sky130_fd_sc_hd__fill_8_679 r0 *1 0,0
Xsky130_fd_sc_hd__fill_8_679 VSS VDD VDD sky130_fd_sc_hd__fill_8
* cell instance sky130_fd_sc_hd__fill_8_680 r0 *1 0,0
Xsky130_fd_sc_hd__fill_8_680 VSS VDD VDD sky130_fd_sc_hd__fill_8
* cell instance sky130_fd_sc_hd__fill_8_681 r0 *1 0,0
Xsky130_fd_sc_hd__fill_8_681 VSS VDD VDD sky130_fd_sc_hd__fill_8
* cell instance sky130_fd_sc_hd__fill_8_682 r0 *1 0,0
Xsky130_fd_sc_hd__fill_8_682 VSS VDD VDD sky130_fd_sc_hd__fill_8
* cell instance sky130_fd_sc_hd__fill_8_683 r0 *1 0,0
Xsky130_fd_sc_hd__fill_8_683 VSS VDD VDD sky130_fd_sc_hd__fill_8
* cell instance sky130_fd_sc_hd__fill_8_684 r0 *1 0,0
Xsky130_fd_sc_hd__fill_8_684 VSS VDD VDD sky130_fd_sc_hd__fill_8
* cell instance sky130_fd_sc_hd__fill_8_685 r0 *1 0,0
Xsky130_fd_sc_hd__fill_8_685 VSS VDD VDD sky130_fd_sc_hd__fill_8
* cell instance sky130_fd_sc_hd__fill_8_686 r0 *1 0,0
Xsky130_fd_sc_hd__fill_8_686 VSS VDD VDD sky130_fd_sc_hd__fill_8
* cell instance sky130_fd_sc_hd__fill_8_687 r0 *1 0,0
Xsky130_fd_sc_hd__fill_8_687 VSS VDD VDD sky130_fd_sc_hd__fill_8
* cell instance sky130_fd_sc_hd__fill_8_688 r0 *1 0,0
Xsky130_fd_sc_hd__fill_8_688 VSS VDD VDD sky130_fd_sc_hd__fill_8
* cell instance sky130_fd_sc_hd__fill_8_689 r0 *1 0,0
Xsky130_fd_sc_hd__fill_8_689 VSS VDD VDD sky130_fd_sc_hd__fill_8
* cell instance sky130_fd_sc_hd__fill_8_690 r0 *1 0,0
Xsky130_fd_sc_hd__fill_8_690 VSS VDD VDD sky130_fd_sc_hd__fill_8
* cell instance sky130_fd_sc_hd__fill_8_691 r0 *1 0,0
Xsky130_fd_sc_hd__fill_8_691 VSS VDD VDD sky130_fd_sc_hd__fill_8
* cell instance sky130_fd_sc_hd__fill_8_692 r0 *1 0,0
Xsky130_fd_sc_hd__fill_8_692 VSS VDD VDD sky130_fd_sc_hd__fill_8
* cell instance sky130_fd_sc_hd__fill_8_693 r0 *1 0,0
Xsky130_fd_sc_hd__fill_8_693 VSS VDD VDD sky130_fd_sc_hd__fill_8
* cell instance sky130_fd_sc_hd__fill_8_694 r0 *1 0,0
Xsky130_fd_sc_hd__fill_8_694 VSS VDD VDD sky130_fd_sc_hd__fill_8
* cell instance sky130_fd_sc_hd__fill_8_695 r0 *1 0,0
Xsky130_fd_sc_hd__fill_8_695 VSS VDD VDD sky130_fd_sc_hd__fill_8
* cell instance sky130_fd_sc_hd__fill_8_696 r0 *1 0,0
Xsky130_fd_sc_hd__fill_8_696 VSS VDD VDD sky130_fd_sc_hd__fill_8
* cell instance sky130_fd_sc_hd__fill_8_697 r0 *1 0,0
Xsky130_fd_sc_hd__fill_8_697 VSS VDD VDD sky130_fd_sc_hd__fill_8
* cell instance sky130_fd_sc_hd__fill_8_698 r0 *1 0,0
Xsky130_fd_sc_hd__fill_8_698 VSS VDD VDD sky130_fd_sc_hd__fill_8
* cell instance sky130_fd_sc_hd__fill_8_699 r0 *1 0,0
Xsky130_fd_sc_hd__fill_8_699 VSS VDD VDD sky130_fd_sc_hd__fill_8
* cell instance sky130_fd_sc_hd__fill_8_700 r0 *1 0,0
Xsky130_fd_sc_hd__fill_8_700 VSS VDD VDD sky130_fd_sc_hd__fill_8
* cell instance sky130_fd_sc_hd__fill_8_701 r0 *1 0,0
Xsky130_fd_sc_hd__fill_8_701 VSS VDD VDD sky130_fd_sc_hd__fill_8
* cell instance sky130_fd_sc_hd__fill_8_702 r0 *1 0,0
Xsky130_fd_sc_hd__fill_8_702 VSS VDD VDD sky130_fd_sc_hd__fill_8
* cell instance sky130_fd_sc_hd__fill_8_703 r0 *1 0,0
Xsky130_fd_sc_hd__fill_8_703 VSS VDD VDD sky130_fd_sc_hd__fill_8
* cell instance sky130_fd_sc_hd__fill_8_704 r0 *1 0,0
Xsky130_fd_sc_hd__fill_8_704 VSS VDD VDD sky130_fd_sc_hd__fill_8
* cell instance sky130_fd_sc_hd__fill_8_705 r0 *1 0,0
Xsky130_fd_sc_hd__fill_8_705 VSS VDD VDD sky130_fd_sc_hd__fill_8
* cell instance sky130_fd_sc_hd__fill_8_706 r0 *1 0,0
Xsky130_fd_sc_hd__fill_8_706 VSS VDD VDD sky130_fd_sc_hd__fill_8
* cell instance sky130_fd_sc_hd__fill_8_707 r0 *1 0,0
Xsky130_fd_sc_hd__fill_8_707 VSS VDD VDD sky130_fd_sc_hd__fill_8
* cell instance sky130_fd_sc_hd__fill_8_708 r0 *1 0,0
Xsky130_fd_sc_hd__fill_8_708 VSS VDD VDD sky130_fd_sc_hd__fill_8
* cell instance sky130_fd_sc_hd__fill_8_709 r0 *1 0,0
Xsky130_fd_sc_hd__fill_8_709 VSS VDD VDD sky130_fd_sc_hd__fill_8
* cell instance sky130_fd_sc_hd__fill_8_710 r0 *1 0,0
Xsky130_fd_sc_hd__fill_8_710 VSS VDD VDD sky130_fd_sc_hd__fill_8
* cell instance sky130_fd_sc_hd__fill_8_711 r0 *1 0,0
Xsky130_fd_sc_hd__fill_8_711 VSS VDD VDD sky130_fd_sc_hd__fill_8
* cell instance sky130_fd_sc_hd__fill_8_712 r0 *1 0,0
Xsky130_fd_sc_hd__fill_8_712 VSS VDD VDD sky130_fd_sc_hd__fill_8
* cell instance sky130_fd_sc_hd__fill_8_713 r0 *1 0,0
Xsky130_fd_sc_hd__fill_8_713 VSS VDD VDD sky130_fd_sc_hd__fill_8
* cell instance sky130_fd_sc_hd__fill_8_714 r0 *1 0,0
Xsky130_fd_sc_hd__fill_8_714 VSS VDD VDD sky130_fd_sc_hd__fill_8
* cell instance sky130_fd_sc_hd__fill_8_715 r0 *1 0,0
Xsky130_fd_sc_hd__fill_8_715 VSS VDD VDD sky130_fd_sc_hd__fill_8
* cell instance sky130_fd_sc_hd__fill_8_716 r0 *1 0,0
Xsky130_fd_sc_hd__fill_8_716 VSS VDD VDD sky130_fd_sc_hd__fill_8
* cell instance sky130_fd_sc_hd__fill_8_717 r0 *1 0,0
Xsky130_fd_sc_hd__fill_8_717 VSS VDD VDD sky130_fd_sc_hd__fill_8
* cell instance sky130_fd_sc_hd__fill_8_718 r0 *1 0,0
Xsky130_fd_sc_hd__fill_8_718 VSS VDD VDD sky130_fd_sc_hd__fill_8
* cell instance sky130_fd_sc_hd__fill_8_719 r0 *1 0,0
Xsky130_fd_sc_hd__fill_8_719 VSS VDD VDD sky130_fd_sc_hd__fill_8
* cell instance sky130_fd_sc_hd__fill_8_720 r0 *1 0,0
Xsky130_fd_sc_hd__fill_8_720 VSS VDD VDD sky130_fd_sc_hd__fill_8
* cell instance sky130_fd_sc_hd__fill_8_721 r0 *1 0,0
Xsky130_fd_sc_hd__fill_8_721 VSS VDD VDD sky130_fd_sc_hd__fill_8
* cell instance sky130_fd_sc_hd__fill_8_722 r0 *1 0,0
Xsky130_fd_sc_hd__fill_8_722 VSS VDD VDD sky130_fd_sc_hd__fill_8
* cell instance sky130_fd_sc_hd__fill_8_723 r0 *1 0,0
Xsky130_fd_sc_hd__fill_8_723 VSS VDD VDD sky130_fd_sc_hd__fill_8
* cell instance sky130_fd_sc_hd__fill_8_724 r0 *1 0,0
Xsky130_fd_sc_hd__fill_8_724 VSS VDD VDD sky130_fd_sc_hd__fill_8
* cell instance sky130_fd_sc_hd__fill_8_725 r0 *1 0,0
Xsky130_fd_sc_hd__fill_8_725 VSS VDD VDD sky130_fd_sc_hd__fill_8
* cell instance sky130_fd_sc_hd__fill_8_726 r0 *1 0,0
Xsky130_fd_sc_hd__fill_8_726 VSS VDD VDD sky130_fd_sc_hd__fill_8
* cell instance sky130_fd_sc_hd__fill_8_727 r0 *1 0,0
Xsky130_fd_sc_hd__fill_8_727 VSS VDD VDD sky130_fd_sc_hd__fill_8
* cell instance sky130_fd_sc_hd__fill_8_728 r0 *1 0,0
Xsky130_fd_sc_hd__fill_8_728 VSS VDD VDD sky130_fd_sc_hd__fill_8
* cell instance sky130_fd_sc_hd__fill_8_729 r0 *1 0,0
Xsky130_fd_sc_hd__fill_8_729 VSS VDD VDD sky130_fd_sc_hd__fill_8
* cell instance sky130_fd_sc_hd__fill_8_730 r0 *1 0,0
Xsky130_fd_sc_hd__fill_8_730 VSS VDD VDD sky130_fd_sc_hd__fill_8
* cell instance sky130_fd_sc_hd__fill_8_731 r0 *1 0,0
Xsky130_fd_sc_hd__fill_8_731 VSS VDD VDD sky130_fd_sc_hd__fill_8
* cell instance sky130_fd_sc_hd__fill_8_732 r0 *1 0,0
Xsky130_fd_sc_hd__fill_8_732 VSS VDD VDD sky130_fd_sc_hd__fill_8
* cell instance sky130_fd_sc_hd__fill_8_733 r0 *1 0,0
Xsky130_fd_sc_hd__fill_8_733 VSS VDD VDD sky130_fd_sc_hd__fill_8
* cell instance sky130_fd_sc_hd__fill_8_734 r0 *1 0,0
Xsky130_fd_sc_hd__fill_8_734 VSS VDD VDD sky130_fd_sc_hd__fill_8
* cell instance sky130_fd_sc_hd__fill_8_735 r0 *1 0,0
Xsky130_fd_sc_hd__fill_8_735 VSS VDD VDD sky130_fd_sc_hd__fill_8
* cell instance sky130_fd_sc_hd__fill_8_736 r0 *1 0,0
Xsky130_fd_sc_hd__fill_8_736 VSS VDD VDD sky130_fd_sc_hd__fill_8
* cell instance sky130_fd_sc_hd__fill_8_737 r0 *1 0,0
Xsky130_fd_sc_hd__fill_8_737 VSS VDD VDD sky130_fd_sc_hd__fill_8
* cell instance sky130_fd_sc_hd__fill_8_738 r0 *1 0,0
Xsky130_fd_sc_hd__fill_8_738 VSS VDD VDD sky130_fd_sc_hd__fill_8
* cell instance sky130_fd_sc_hd__fill_8_739 r0 *1 0,0
Xsky130_fd_sc_hd__fill_8_739 VSS VDD VDD sky130_fd_sc_hd__fill_8
* cell instance sky130_fd_sc_hd__fill_8_740 r0 *1 0,0
Xsky130_fd_sc_hd__fill_8_740 VSS VDD VDD sky130_fd_sc_hd__fill_8
* cell instance sky130_fd_sc_hd__fill_8_741 r0 *1 0,0
Xsky130_fd_sc_hd__fill_8_741 VSS VDD VDD sky130_fd_sc_hd__fill_8
* cell instance sky130_fd_sc_hd__fill_8_742 r0 *1 0,0
Xsky130_fd_sc_hd__fill_8_742 VSS VDD VDD sky130_fd_sc_hd__fill_8
* cell instance sky130_fd_sc_hd__fill_8_743 r0 *1 0,0
Xsky130_fd_sc_hd__fill_8_743 VSS VDD VDD sky130_fd_sc_hd__fill_8
* cell instance sky130_fd_sc_hd__fill_8_744 r0 *1 0,0
Xsky130_fd_sc_hd__fill_8_744 VSS VDD VDD sky130_fd_sc_hd__fill_8
* cell instance sky130_fd_sc_hd__fill_8_745 r0 *1 0,0
Xsky130_fd_sc_hd__fill_8_745 VSS VDD VDD sky130_fd_sc_hd__fill_8
* cell instance sky130_fd_sc_hd__fill_8_746 r0 *1 0,0
Xsky130_fd_sc_hd__fill_8_746 VSS VDD VDD sky130_fd_sc_hd__fill_8
* cell instance sky130_fd_sc_hd__fill_8_747 r0 *1 0,0
Xsky130_fd_sc_hd__fill_8_747 VSS VDD VDD sky130_fd_sc_hd__fill_8
* cell instance sky130_fd_sc_hd__fill_8_748 r0 *1 0,0
Xsky130_fd_sc_hd__fill_8_748 VSS VDD VDD sky130_fd_sc_hd__fill_8
* cell instance sky130_fd_sc_hd__fill_8_749 r0 *1 0,0
Xsky130_fd_sc_hd__fill_8_749 VSS VDD VDD sky130_fd_sc_hd__fill_8
* cell instance sky130_fd_sc_hd__fill_8_750 r0 *1 0,0
Xsky130_fd_sc_hd__fill_8_750 VSS VDD VDD sky130_fd_sc_hd__fill_8
* cell instance sky130_fd_sc_hd__fill_8_751 r0 *1 0,0
Xsky130_fd_sc_hd__fill_8_751 VSS VDD VDD sky130_fd_sc_hd__fill_8
* cell instance sky130_fd_sc_hd__fill_8_752 r0 *1 0,0
Xsky130_fd_sc_hd__fill_8_752 VSS VDD VDD sky130_fd_sc_hd__fill_8
* cell instance sky130_fd_sc_hd__fill_8_753 r0 *1 0,0
Xsky130_fd_sc_hd__fill_8_753 VSS VDD VDD sky130_fd_sc_hd__fill_8
* cell instance sky130_fd_sc_hd__fill_8_754 r0 *1 0,0
Xsky130_fd_sc_hd__fill_8_754 VSS VDD VDD sky130_fd_sc_hd__fill_8
* cell instance sky130_fd_sc_hd__fill_8_755 r0 *1 0,0
Xsky130_fd_sc_hd__fill_8_755 VSS VDD VDD sky130_fd_sc_hd__fill_8
* cell instance sky130_fd_sc_hd__fill_8_756 r0 *1 0,0
Xsky130_fd_sc_hd__fill_8_756 VSS VDD VDD sky130_fd_sc_hd__fill_8
* cell instance sky130_fd_sc_hd__fill_8_757 r0 *1 0,0
Xsky130_fd_sc_hd__fill_8_757 VSS VDD VDD sky130_fd_sc_hd__fill_8
* cell instance sky130_fd_sc_hd__fill_8_758 r0 *1 0,0
Xsky130_fd_sc_hd__fill_8_758 VSS VDD VDD sky130_fd_sc_hd__fill_8
* cell instance sky130_fd_sc_hd__fill_8_759 r0 *1 0,0
Xsky130_fd_sc_hd__fill_8_759 VSS VDD VDD sky130_fd_sc_hd__fill_8
* cell instance sky130_fd_sc_hd__fill_8_760 r0 *1 0,0
Xsky130_fd_sc_hd__fill_8_760 VSS VDD VDD sky130_fd_sc_hd__fill_8
* cell instance sky130_fd_sc_hd__fill_8_761 r0 *1 0,0
Xsky130_fd_sc_hd__fill_8_761 VSS VDD VDD sky130_fd_sc_hd__fill_8
* cell instance sky130_fd_sc_hd__fill_8_762 r0 *1 0,0
Xsky130_fd_sc_hd__fill_8_762 VSS VDD VDD sky130_fd_sc_hd__fill_8
* cell instance sky130_fd_sc_hd__fill_8_763 r0 *1 0,0
Xsky130_fd_sc_hd__fill_8_763 VSS VDD VDD sky130_fd_sc_hd__fill_8
* cell instance sky130_fd_sc_hd__fill_8_764 r0 *1 0,0
Xsky130_fd_sc_hd__fill_8_764 VSS VDD VDD sky130_fd_sc_hd__fill_8
* cell instance sky130_fd_sc_hd__fill_8_765 r0 *1 0,0
Xsky130_fd_sc_hd__fill_8_765 VSS VDD VDD sky130_fd_sc_hd__fill_8
* cell instance sky130_fd_sc_hd__fill_8_766 r0 *1 0,0
Xsky130_fd_sc_hd__fill_8_766 VSS VDD VDD sky130_fd_sc_hd__fill_8
* cell instance sky130_fd_sc_hd__fill_8_767 r0 *1 0,0
Xsky130_fd_sc_hd__fill_8_767 VSS VDD VDD sky130_fd_sc_hd__fill_8
* cell instance sky130_fd_sc_hd__fill_8_768 r0 *1 0,0
Xsky130_fd_sc_hd__fill_8_768 VSS VDD VDD sky130_fd_sc_hd__fill_8
* cell instance sky130_fd_sc_hd__fill_8_769 r0 *1 0,0
Xsky130_fd_sc_hd__fill_8_769 VSS VDD VDD sky130_fd_sc_hd__fill_8
* cell instance sky130_fd_sc_hd__fill_8_770 r0 *1 0,0
Xsky130_fd_sc_hd__fill_8_770 VSS VDD VDD sky130_fd_sc_hd__fill_8
* cell instance sky130_fd_sc_hd__fill_8_771 r0 *1 0,0
Xsky130_fd_sc_hd__fill_8_771 VSS VDD VDD sky130_fd_sc_hd__fill_8
* cell instance sky130_fd_sc_hd__fill_8_772 r0 *1 0,0
Xsky130_fd_sc_hd__fill_8_772 VSS VDD VDD sky130_fd_sc_hd__fill_8
* cell instance sky130_fd_sc_hd__fill_8_773 r0 *1 0,0
Xsky130_fd_sc_hd__fill_8_773 VSS VDD VDD sky130_fd_sc_hd__fill_8
* cell instance sky130_fd_sc_hd__fill_8_774 r0 *1 0,0
Xsky130_fd_sc_hd__fill_8_774 VSS VDD VDD sky130_fd_sc_hd__fill_8
* cell instance sky130_fd_sc_hd__fill_8_775 r0 *1 0,0
Xsky130_fd_sc_hd__fill_8_775 VSS VDD VDD sky130_fd_sc_hd__fill_8
* cell instance sky130_fd_sc_hd__fill_8_776 r0 *1 0,0
Xsky130_fd_sc_hd__fill_8_776 VSS VDD VDD sky130_fd_sc_hd__fill_8
* cell instance sky130_fd_sc_hd__fill_8_777 r0 *1 0,0
Xsky130_fd_sc_hd__fill_8_777 VSS VDD VDD sky130_fd_sc_hd__fill_8
* cell instance sky130_fd_sc_hd__fill_8_778 r0 *1 0,0
Xsky130_fd_sc_hd__fill_8_778 VSS VDD VDD sky130_fd_sc_hd__fill_8
* cell instance sky130_fd_sc_hd__fill_8_779 r0 *1 0,0
Xsky130_fd_sc_hd__fill_8_779 VSS VDD VDD sky130_fd_sc_hd__fill_8
* cell instance sky130_fd_sc_hd__fill_8_780 r0 *1 0,0
Xsky130_fd_sc_hd__fill_8_780 VSS VDD VDD sky130_fd_sc_hd__fill_8
* cell instance sky130_fd_sc_hd__fill_8_781 r0 *1 0,0
Xsky130_fd_sc_hd__fill_8_781 VSS VDD VDD sky130_fd_sc_hd__fill_8
* cell instance sky130_fd_sc_hd__fill_8_782 r0 *1 0,0
Xsky130_fd_sc_hd__fill_8_782 VSS VDD VDD sky130_fd_sc_hd__fill_8
* cell instance sky130_fd_sc_hd__fill_8_783 r0 *1 0,0
Xsky130_fd_sc_hd__fill_8_783 VSS VDD VDD sky130_fd_sc_hd__fill_8
* cell instance sky130_fd_sc_hd__fill_8_784 r0 *1 0,0
Xsky130_fd_sc_hd__fill_8_784 VSS VDD VDD sky130_fd_sc_hd__fill_8
* cell instance sky130_fd_sc_hd__fill_8_785 r0 *1 0,0
Xsky130_fd_sc_hd__fill_8_785 VSS VDD VDD sky130_fd_sc_hd__fill_8
* cell instance sky130_fd_sc_hd__fill_8_786 r0 *1 0,0
Xsky130_fd_sc_hd__fill_8_786 VSS VDD VDD sky130_fd_sc_hd__fill_8
* cell instance sky130_fd_sc_hd__fill_8_787 r0 *1 0,0
Xsky130_fd_sc_hd__fill_8_787 VSS VDD VDD sky130_fd_sc_hd__fill_8
* cell instance sky130_fd_sc_hd__fill_8_788 r0 *1 0,0
Xsky130_fd_sc_hd__fill_8_788 VSS VDD VDD sky130_fd_sc_hd__fill_8
* cell instance sky130_fd_sc_hd__fill_8_789 r0 *1 0,0
Xsky130_fd_sc_hd__fill_8_789 VSS VDD VDD sky130_fd_sc_hd__fill_8
* cell instance sky130_fd_sc_hd__fill_8_790 r0 *1 0,0
Xsky130_fd_sc_hd__fill_8_790 VSS VDD VDD sky130_fd_sc_hd__fill_8
* cell instance sky130_fd_sc_hd__fill_8_791 r0 *1 0,0
Xsky130_fd_sc_hd__fill_8_791 VSS VDD VDD sky130_fd_sc_hd__fill_8
* cell instance sky130_fd_sc_hd__fill_8_792 r0 *1 0,0
Xsky130_fd_sc_hd__fill_8_792 VSS VDD VDD sky130_fd_sc_hd__fill_8
* cell instance sky130_fd_sc_hd__fill_8_793 r0 *1 0,0
Xsky130_fd_sc_hd__fill_8_793 VSS VDD VDD sky130_fd_sc_hd__fill_8
* cell instance sky130_fd_sc_hd__fill_8_794 r0 *1 0,0
Xsky130_fd_sc_hd__fill_8_794 VSS VDD VDD sky130_fd_sc_hd__fill_8
* cell instance sky130_fd_sc_hd__fill_8_795 r0 *1 0,0
Xsky130_fd_sc_hd__fill_8_795 VSS VDD VDD sky130_fd_sc_hd__fill_8
* cell instance sky130_fd_sc_hd__fill_8_796 r0 *1 0,0
Xsky130_fd_sc_hd__fill_8_796 VSS VDD VDD sky130_fd_sc_hd__fill_8
* cell instance sky130_fd_sc_hd__fill_8_797 r0 *1 0,0
Xsky130_fd_sc_hd__fill_8_797 VSS VDD VDD sky130_fd_sc_hd__fill_8
* cell instance sky130_fd_sc_hd__fill_8_798 r0 *1 0,0
Xsky130_fd_sc_hd__fill_8_798 VSS VDD VDD sky130_fd_sc_hd__fill_8
* cell instance sky130_fd_sc_hd__fill_8_799 r0 *1 0,0
Xsky130_fd_sc_hd__fill_8_799 VSS VDD VDD sky130_fd_sc_hd__fill_8
* cell instance sky130_fd_sc_hd__fill_8_800 r0 *1 0,0
Xsky130_fd_sc_hd__fill_8_800 VSS VDD VDD sky130_fd_sc_hd__fill_8
* cell instance sky130_fd_sc_hd__fill_8_801 r0 *1 0,0
Xsky130_fd_sc_hd__fill_8_801 VSS VDD VDD sky130_fd_sc_hd__fill_8
* cell instance sky130_fd_sc_hd__fill_8_802 r0 *1 0,0
Xsky130_fd_sc_hd__fill_8_802 VSS VDD VDD sky130_fd_sc_hd__fill_8
* cell instance sky130_fd_sc_hd__fill_8_803 r0 *1 0,0
Xsky130_fd_sc_hd__fill_8_803 VSS VDD VDD sky130_fd_sc_hd__fill_8
* cell instance sky130_fd_sc_hd__fill_8_804 r0 *1 0,0
Xsky130_fd_sc_hd__fill_8_804 VSS VDD VDD sky130_fd_sc_hd__fill_8
* cell instance sky130_fd_sc_hd__fill_8_805 r0 *1 0,0
Xsky130_fd_sc_hd__fill_8_805 VSS VDD VDD sky130_fd_sc_hd__fill_8
* cell instance sky130_fd_sc_hd__fill_8_806 r0 *1 0,0
Xsky130_fd_sc_hd__fill_8_806 VSS VDD VDD sky130_fd_sc_hd__fill_8
* cell instance sky130_fd_sc_hd__fill_8_807 r0 *1 0,0
Xsky130_fd_sc_hd__fill_8_807 VSS VDD VDD sky130_fd_sc_hd__fill_8
* cell instance sky130_fd_sc_hd__fill_8_808 r0 *1 0,0
Xsky130_fd_sc_hd__fill_8_808 VSS VDD VDD sky130_fd_sc_hd__fill_8
* cell instance sky130_fd_sc_hd__fill_8_809 r0 *1 0,0
Xsky130_fd_sc_hd__fill_8_809 VSS VDD VDD sky130_fd_sc_hd__fill_8
* cell instance sky130_fd_sc_hd__fill_8_810 r0 *1 0,0
Xsky130_fd_sc_hd__fill_8_810 VSS VDD VDD sky130_fd_sc_hd__fill_8
* cell instance sky130_fd_sc_hd__fill_8_811 r0 *1 0,0
Xsky130_fd_sc_hd__fill_8_811 VSS VDD VDD sky130_fd_sc_hd__fill_8
* cell instance sky130_fd_sc_hd__fill_8_812 r0 *1 0,0
Xsky130_fd_sc_hd__fill_8_812 VSS VDD VDD sky130_fd_sc_hd__fill_8
* cell instance sky130_fd_sc_hd__fill_8_813 r0 *1 0,0
Xsky130_fd_sc_hd__fill_8_813 VSS VDD VDD sky130_fd_sc_hd__fill_8
* cell instance sky130_fd_sc_hd__fill_8_814 r0 *1 0,0
Xsky130_fd_sc_hd__fill_8_814 VSS VDD VDD sky130_fd_sc_hd__fill_8
* cell instance sky130_fd_sc_hd__fill_8_815 r0 *1 0,0
Xsky130_fd_sc_hd__fill_8_815 VSS VDD VDD sky130_fd_sc_hd__fill_8
* cell instance sky130_fd_sc_hd__fill_8_816 r0 *1 0,0
Xsky130_fd_sc_hd__fill_8_816 VSS VDD VDD sky130_fd_sc_hd__fill_8
* cell instance sky130_fd_sc_hd__fill_8_817 r0 *1 0,0
Xsky130_fd_sc_hd__fill_8_817 VSS VDD VDD sky130_fd_sc_hd__fill_8
* cell instance sky130_fd_sc_hd__fill_8_818 r0 *1 0,0
Xsky130_fd_sc_hd__fill_8_818 VSS VDD VDD sky130_fd_sc_hd__fill_8
* cell instance sky130_fd_sc_hd__fill_8_819 r0 *1 0,0
Xsky130_fd_sc_hd__fill_8_819 VSS VDD VDD sky130_fd_sc_hd__fill_8
* cell instance sky130_fd_sc_hd__fill_8_820 r0 *1 0,0
Xsky130_fd_sc_hd__fill_8_820 VSS VDD VDD sky130_fd_sc_hd__fill_8
* cell instance sky130_fd_sc_hd__fill_8_821 r0 *1 0,0
Xsky130_fd_sc_hd__fill_8_821 VSS VDD VDD sky130_fd_sc_hd__fill_8
* cell instance sky130_fd_sc_hd__fill_8_822 r0 *1 0,0
Xsky130_fd_sc_hd__fill_8_822 VSS VDD VDD sky130_fd_sc_hd__fill_8
* cell instance sky130_fd_sc_hd__fill_8_823 r0 *1 0,0
Xsky130_fd_sc_hd__fill_8_823 VSS VDD VDD sky130_fd_sc_hd__fill_8
* cell instance sky130_fd_sc_hd__fill_8_824 r0 *1 0,0
Xsky130_fd_sc_hd__fill_8_824 VSS VDD VDD sky130_fd_sc_hd__fill_8
* cell instance sky130_fd_sc_hd__fill_8_825 r0 *1 0,0
Xsky130_fd_sc_hd__fill_8_825 VSS VDD VDD sky130_fd_sc_hd__fill_8
* cell instance sky130_fd_sc_hd__fill_8_826 r0 *1 0,0
Xsky130_fd_sc_hd__fill_8_826 VSS VDD VDD sky130_fd_sc_hd__fill_8
* cell instance sky130_fd_sc_hd__fill_8_827 r0 *1 0,0
Xsky130_fd_sc_hd__fill_8_827 VSS VDD VDD sky130_fd_sc_hd__fill_8
* cell instance sky130_fd_sc_hd__fill_8_828 r0 *1 0,0
Xsky130_fd_sc_hd__fill_8_828 VSS VDD VDD sky130_fd_sc_hd__fill_8
* cell instance sky130_fd_sc_hd__fill_8_829 r0 *1 0,0
Xsky130_fd_sc_hd__fill_8_829 VSS VDD VDD sky130_fd_sc_hd__fill_8
* cell instance sky130_fd_sc_hd__fill_8_830 r0 *1 0,0
Xsky130_fd_sc_hd__fill_8_830 VSS VDD VDD sky130_fd_sc_hd__fill_8
* cell instance sky130_fd_sc_hd__fill_8_831 r0 *1 0,0
Xsky130_fd_sc_hd__fill_8_831 VSS VDD VDD sky130_fd_sc_hd__fill_8
* cell instance sky130_fd_sc_hd__fill_8_832 r0 *1 0,0
Xsky130_fd_sc_hd__fill_8_832 VSS VDD VDD sky130_fd_sc_hd__fill_8
* cell instance sky130_fd_sc_hd__fill_8_833 r0 *1 0,0
Xsky130_fd_sc_hd__fill_8_833 VSS VDD VDD sky130_fd_sc_hd__fill_8
* cell instance sky130_fd_sc_hd__fill_8_834 r0 *1 0,0
Xsky130_fd_sc_hd__fill_8_834 VSS VDD VDD sky130_fd_sc_hd__fill_8
* cell instance sky130_fd_sc_hd__fill_8_835 r0 *1 0,0
Xsky130_fd_sc_hd__fill_8_835 VSS VDD VDD sky130_fd_sc_hd__fill_8
* cell instance sky130_fd_sc_hd__fill_8_836 r0 *1 0,0
Xsky130_fd_sc_hd__fill_8_836 VSS VDD VDD sky130_fd_sc_hd__fill_8
* cell instance sky130_fd_sc_hd__fill_8_837 r0 *1 0,0
Xsky130_fd_sc_hd__fill_8_837 VSS VDD VDD sky130_fd_sc_hd__fill_8
* cell instance sky130_fd_sc_hd__fill_8_838 r0 *1 0,0
Xsky130_fd_sc_hd__fill_8_838 VSS VDD VDD sky130_fd_sc_hd__fill_8
* cell instance sky130_fd_sc_hd__fill_8_839 r0 *1 0,0
Xsky130_fd_sc_hd__fill_8_839 VSS VDD VDD sky130_fd_sc_hd__fill_8
* cell instance sky130_fd_sc_hd__fill_8_840 r0 *1 0,0
Xsky130_fd_sc_hd__fill_8_840 VSS VDD VDD sky130_fd_sc_hd__fill_8
* cell instance sky130_fd_sc_hd__fill_8_841 r0 *1 0,0
Xsky130_fd_sc_hd__fill_8_841 VSS VDD VDD sky130_fd_sc_hd__fill_8
* cell instance sky130_fd_sc_hd__fill_8_842 r0 *1 0,0
Xsky130_fd_sc_hd__fill_8_842 VSS VDD VDD sky130_fd_sc_hd__fill_8
* cell instance sky130_fd_sc_hd__fill_8_843 r0 *1 0,0
Xsky130_fd_sc_hd__fill_8_843 VSS VDD VDD sky130_fd_sc_hd__fill_8
* cell instance sky130_fd_sc_hd__fill_8_844 r0 *1 0,0
Xsky130_fd_sc_hd__fill_8_844 VSS VDD VDD sky130_fd_sc_hd__fill_8
* cell instance sky130_fd_sc_hd__fill_8_845 r0 *1 0,0
Xsky130_fd_sc_hd__fill_8_845 VSS VDD VDD sky130_fd_sc_hd__fill_8
* cell instance sky130_fd_sc_hd__fill_8_846 r0 *1 0,0
Xsky130_fd_sc_hd__fill_8_846 VSS VDD VDD sky130_fd_sc_hd__fill_8
* cell instance sky130_fd_sc_hd__fill_8_847 r0 *1 0,0
Xsky130_fd_sc_hd__fill_8_847 VSS VDD VDD sky130_fd_sc_hd__fill_8
* cell instance sky130_fd_sc_hd__fill_8_848 r0 *1 0,0
Xsky130_fd_sc_hd__fill_8_848 VSS VDD VDD sky130_fd_sc_hd__fill_8
* cell instance sky130_fd_sc_hd__fill_8_849 r0 *1 0,0
Xsky130_fd_sc_hd__fill_8_849 VSS VDD VDD sky130_fd_sc_hd__fill_8
* cell instance sky130_fd_sc_hd__fill_8_850 r0 *1 0,0
Xsky130_fd_sc_hd__fill_8_850 VSS VDD VDD sky130_fd_sc_hd__fill_8
* cell instance sky130_fd_sc_hd__fill_8_851 r0 *1 0,0
Xsky130_fd_sc_hd__fill_8_851 VSS VDD VDD sky130_fd_sc_hd__fill_8
* cell instance sky130_fd_sc_hd__fill_8_852 r0 *1 0,0
Xsky130_fd_sc_hd__fill_8_852 VSS VDD VDD sky130_fd_sc_hd__fill_8
* cell instance sky130_fd_sc_hd__fill_8_853 r0 *1 0,0
Xsky130_fd_sc_hd__fill_8_853 VSS VDD VDD sky130_fd_sc_hd__fill_8
* cell instance sky130_fd_sc_hd__fill_8_854 r0 *1 0,0
Xsky130_fd_sc_hd__fill_8_854 VSS VDD VDD sky130_fd_sc_hd__fill_8
* cell instance sky130_fd_sc_hd__fill_8_855 r0 *1 0,0
Xsky130_fd_sc_hd__fill_8_855 VSS VDD VDD sky130_fd_sc_hd__fill_8
* cell instance sky130_fd_sc_hd__fill_8_856 r0 *1 0,0
Xsky130_fd_sc_hd__fill_8_856 VSS VDD VDD sky130_fd_sc_hd__fill_8
* cell instance sky130_fd_sc_hd__fill_8_857 r0 *1 0,0
Xsky130_fd_sc_hd__fill_8_857 VSS VDD VDD sky130_fd_sc_hd__fill_8
* cell instance sky130_fd_sc_hd__fill_8_858 r0 *1 0,0
Xsky130_fd_sc_hd__fill_8_858 VSS VDD VDD sky130_fd_sc_hd__fill_8
* cell instance sky130_fd_sc_hd__fill_8_859 r0 *1 0,0
Xsky130_fd_sc_hd__fill_8_859 VSS VDD VDD sky130_fd_sc_hd__fill_8
* cell instance sky130_fd_sc_hd__fill_8_860 r0 *1 0,0
Xsky130_fd_sc_hd__fill_8_860 VSS VDD VDD sky130_fd_sc_hd__fill_8
* cell instance sky130_fd_sc_hd__fill_8_861 r0 *1 0,0
Xsky130_fd_sc_hd__fill_8_861 VSS VDD VDD sky130_fd_sc_hd__fill_8
* cell instance sky130_fd_sc_hd__fill_8_862 r0 *1 0,0
Xsky130_fd_sc_hd__fill_8_862 VSS VDD VDD sky130_fd_sc_hd__fill_8
* cell instance sky130_fd_sc_hd__fill_8_863 r0 *1 0,0
Xsky130_fd_sc_hd__fill_8_863 VSS VDD VDD sky130_fd_sc_hd__fill_8
* cell instance sky130_fd_sc_hd__fill_8_864 r0 *1 0,0
Xsky130_fd_sc_hd__fill_8_864 VSS VDD VDD sky130_fd_sc_hd__fill_8
* cell instance sky130_fd_sc_hd__fill_8_865 r0 *1 0,0
Xsky130_fd_sc_hd__fill_8_865 VSS VDD VDD sky130_fd_sc_hd__fill_8
* cell instance sky130_fd_sc_hd__fill_8_866 r0 *1 0,0
Xsky130_fd_sc_hd__fill_8_866 VSS VDD VDD sky130_fd_sc_hd__fill_8
* cell instance sky130_fd_sc_hd__fill_8_867 r0 *1 0,0
Xsky130_fd_sc_hd__fill_8_867 VSS VDD VDD sky130_fd_sc_hd__fill_8
* cell instance sky130_fd_sc_hd__fill_8_868 r0 *1 0,0
Xsky130_fd_sc_hd__fill_8_868 VSS VDD VDD sky130_fd_sc_hd__fill_8
* cell instance sky130_fd_sc_hd__fill_8_869 r0 *1 0,0
Xsky130_fd_sc_hd__fill_8_869 VSS VDD VDD sky130_fd_sc_hd__fill_8
* cell instance sky130_fd_sc_hd__fill_8_870 r0 *1 0,0
Xsky130_fd_sc_hd__fill_8_870 VSS VDD VDD sky130_fd_sc_hd__fill_8
* cell instance sky130_fd_sc_hd__fill_8_871 r0 *1 0,0
Xsky130_fd_sc_hd__fill_8_871 VSS VDD VDD sky130_fd_sc_hd__fill_8
* cell instance sky130_fd_sc_hd__fill_8_872 r0 *1 0,0
Xsky130_fd_sc_hd__fill_8_872 VSS VDD VDD sky130_fd_sc_hd__fill_8
* cell instance sky130_fd_sc_hd__fill_8_873 r0 *1 0,0
Xsky130_fd_sc_hd__fill_8_873 VSS VDD VDD sky130_fd_sc_hd__fill_8
* cell instance sky130_fd_sc_hd__fill_8_874 r0 *1 0,0
Xsky130_fd_sc_hd__fill_8_874 VSS VDD VDD sky130_fd_sc_hd__fill_8
* cell instance sky130_fd_sc_hd__fill_8_875 r0 *1 0,0
Xsky130_fd_sc_hd__fill_8_875 VSS VDD VDD sky130_fd_sc_hd__fill_8
* cell instance sky130_fd_sc_hd__fill_8_876 r0 *1 0,0
Xsky130_fd_sc_hd__fill_8_876 VSS VDD VDD sky130_fd_sc_hd__fill_8
* cell instance sky130_fd_sc_hd__fill_8_877 r0 *1 0,0
Xsky130_fd_sc_hd__fill_8_877 VSS VDD VDD sky130_fd_sc_hd__fill_8
* cell instance sky130_fd_sc_hd__fill_8_878 r0 *1 0,0
Xsky130_fd_sc_hd__fill_8_878 VSS VDD VDD sky130_fd_sc_hd__fill_8
* cell instance sky130_fd_sc_hd__fill_8_879 r0 *1 0,0
Xsky130_fd_sc_hd__fill_8_879 VSS VDD VDD sky130_fd_sc_hd__fill_8
* cell instance sky130_fd_sc_hd__fill_8_880 r0 *1 0,0
Xsky130_fd_sc_hd__fill_8_880 VSS VDD VDD sky130_fd_sc_hd__fill_8
* cell instance sky130_fd_sc_hd__fill_8_881 r0 *1 0,0
Xsky130_fd_sc_hd__fill_8_881 VSS VDD VDD sky130_fd_sc_hd__fill_8
* cell instance sky130_fd_sc_hd__fill_8_882 r0 *1 0,0
Xsky130_fd_sc_hd__fill_8_882 VSS VDD VDD sky130_fd_sc_hd__fill_8
* cell instance sky130_fd_sc_hd__fill_8_883 r0 *1 0,0
Xsky130_fd_sc_hd__fill_8_883 VSS VDD VDD sky130_fd_sc_hd__fill_8
* cell instance sky130_fd_sc_hd__fill_8_884 r0 *1 0,0
Xsky130_fd_sc_hd__fill_8_884 VSS VDD VDD sky130_fd_sc_hd__fill_8
* cell instance sky130_fd_sc_hd__fill_8_885 r0 *1 0,0
Xsky130_fd_sc_hd__fill_8_885 VSS VDD VDD sky130_fd_sc_hd__fill_8
* cell instance sky130_fd_sc_hd__fill_8_886 r0 *1 0,0
Xsky130_fd_sc_hd__fill_8_886 VSS VDD VDD sky130_fd_sc_hd__fill_8
* cell instance sky130_fd_sc_hd__fill_8_887 r0 *1 0,0
Xsky130_fd_sc_hd__fill_8_887 VSS VDD VDD sky130_fd_sc_hd__fill_8
* cell instance sky130_fd_sc_hd__fill_8_888 r0 *1 0,0
Xsky130_fd_sc_hd__fill_8_888 VSS VDD VDD sky130_fd_sc_hd__fill_8
* cell instance sky130_fd_sc_hd__fill_8_889 r0 *1 0,0
Xsky130_fd_sc_hd__fill_8_889 VSS VDD VDD sky130_fd_sc_hd__fill_8
* cell instance sky130_fd_sc_hd__fill_8_890 r0 *1 0,0
Xsky130_fd_sc_hd__fill_8_890 VSS VDD VDD sky130_fd_sc_hd__fill_8
* cell instance sky130_fd_sc_hd__fill_8_891 r0 *1 0,0
Xsky130_fd_sc_hd__fill_8_891 VSS VDD VDD sky130_fd_sc_hd__fill_8
* cell instance sky130_fd_sc_hd__fill_8_892 r0 *1 0,0
Xsky130_fd_sc_hd__fill_8_892 VSS VDD VDD sky130_fd_sc_hd__fill_8
* cell instance sky130_fd_sc_hd__fill_8_893 r0 *1 0,0
Xsky130_fd_sc_hd__fill_8_893 VSS VDD VDD sky130_fd_sc_hd__fill_8
* cell instance sky130_fd_sc_hd__fill_8_894 r0 *1 0,0
Xsky130_fd_sc_hd__fill_8_894 VSS VDD VDD sky130_fd_sc_hd__fill_8
* cell instance sky130_fd_sc_hd__fill_8_895 r0 *1 0,0
Xsky130_fd_sc_hd__fill_8_895 VSS VDD VDD sky130_fd_sc_hd__fill_8
* cell instance sky130_fd_sc_hd__fill_8_896 r0 *1 0,0
Xsky130_fd_sc_hd__fill_8_896 VSS VDD VDD sky130_fd_sc_hd__fill_8
* cell instance sky130_fd_sc_hd__fill_8_897 r0 *1 0,0
Xsky130_fd_sc_hd__fill_8_897 VSS VDD VDD sky130_fd_sc_hd__fill_8
* cell instance sky130_fd_sc_hd__fill_8_898 r0 *1 0,0
Xsky130_fd_sc_hd__fill_8_898 VSS VDD VDD sky130_fd_sc_hd__fill_8
* cell instance sky130_fd_sc_hd__fill_8_899 r0 *1 0,0
Xsky130_fd_sc_hd__fill_8_899 VSS VDD VDD sky130_fd_sc_hd__fill_8
* cell instance sky130_fd_sc_hd__fill_8_900 r0 *1 0,0
Xsky130_fd_sc_hd__fill_8_900 VSS VDD VDD sky130_fd_sc_hd__fill_8
* cell instance sky130_fd_sc_hd__fill_8_901 r0 *1 0,0
Xsky130_fd_sc_hd__fill_8_901 VSS VDD VDD sky130_fd_sc_hd__fill_8
* cell instance sky130_fd_sc_hd__fill_8_902 r0 *1 0,0
Xsky130_fd_sc_hd__fill_8_902 VSS VDD VDD sky130_fd_sc_hd__fill_8
* cell instance sky130_fd_sc_hd__fill_8_903 r0 *1 0,0
Xsky130_fd_sc_hd__fill_8_903 VSS VDD VDD sky130_fd_sc_hd__fill_8
* cell instance sky130_fd_sc_hd__fill_8_904 r0 *1 0,0
Xsky130_fd_sc_hd__fill_8_904 VSS VDD VDD sky130_fd_sc_hd__fill_8
* cell instance sky130_fd_sc_hd__fill_8_905 r0 *1 0,0
Xsky130_fd_sc_hd__fill_8_905 VSS VDD VDD sky130_fd_sc_hd__fill_8
* cell instance sky130_fd_sc_hd__fill_8_906 r0 *1 0,0
Xsky130_fd_sc_hd__fill_8_906 VSS VDD VDD sky130_fd_sc_hd__fill_8
* cell instance sky130_fd_sc_hd__fill_8_907 r0 *1 0,0
Xsky130_fd_sc_hd__fill_8_907 VSS VDD VDD sky130_fd_sc_hd__fill_8
* cell instance sky130_fd_sc_hd__fill_8_908 r0 *1 0,0
Xsky130_fd_sc_hd__fill_8_908 VSS VDD VDD sky130_fd_sc_hd__fill_8
* cell instance sky130_fd_sc_hd__fill_8_909 r0 *1 0,0
Xsky130_fd_sc_hd__fill_8_909 VSS VDD VDD sky130_fd_sc_hd__fill_8
* cell instance sky130_fd_sc_hd__fill_8_910 r0 *1 0,0
Xsky130_fd_sc_hd__fill_8_910 VSS VDD VDD sky130_fd_sc_hd__fill_8
* cell instance sky130_fd_sc_hd__fill_8_911 r0 *1 0,0
Xsky130_fd_sc_hd__fill_8_911 VSS VDD VDD sky130_fd_sc_hd__fill_8
* cell instance sky130_fd_sc_hd__fill_8_912 r0 *1 0,0
Xsky130_fd_sc_hd__fill_8_912 VSS VDD VDD sky130_fd_sc_hd__fill_8
* cell instance sky130_fd_sc_hd__fill_8_913 r0 *1 0,0
Xsky130_fd_sc_hd__fill_8_913 VSS VDD VDD sky130_fd_sc_hd__fill_8
* cell instance sky130_fd_sc_hd__fill_8_914 r0 *1 0,0
Xsky130_fd_sc_hd__fill_8_914 VSS VDD VDD sky130_fd_sc_hd__fill_8
* cell instance sky130_fd_sc_hd__fill_8_915 r0 *1 0,0
Xsky130_fd_sc_hd__fill_8_915 VSS VDD VDD sky130_fd_sc_hd__fill_8
* cell instance sky130_fd_sc_hd__fill_8_916 r0 *1 0,0
Xsky130_fd_sc_hd__fill_8_916 VSS VDD VDD sky130_fd_sc_hd__fill_8
* cell instance sky130_fd_sc_hd__fill_8_917 r0 *1 0,0
Xsky130_fd_sc_hd__fill_8_917 VSS VDD VDD sky130_fd_sc_hd__fill_8
* cell instance sky130_fd_sc_hd__fill_8_918 r0 *1 0,0
Xsky130_fd_sc_hd__fill_8_918 VSS VDD VDD sky130_fd_sc_hd__fill_8
* cell instance sky130_fd_sc_hd__fill_8_919 r0 *1 0,0
Xsky130_fd_sc_hd__fill_8_919 VSS VDD VDD sky130_fd_sc_hd__fill_8
* cell instance sky130_fd_sc_hd__fill_8_920 r0 *1 0,0
Xsky130_fd_sc_hd__fill_8_920 VSS VDD VDD sky130_fd_sc_hd__fill_8
* cell instance sky130_fd_sc_hd__fill_8_921 r0 *1 0,0
Xsky130_fd_sc_hd__fill_8_921 VSS VDD VDD sky130_fd_sc_hd__fill_8
* cell instance sky130_fd_sc_hd__fill_8_922 r0 *1 0,0
Xsky130_fd_sc_hd__fill_8_922 VSS VDD VDD sky130_fd_sc_hd__fill_8
* cell instance sky130_fd_sc_hd__fill_8_923 r0 *1 0,0
Xsky130_fd_sc_hd__fill_8_923 VSS VDD VDD sky130_fd_sc_hd__fill_8
* cell instance sky130_fd_sc_hd__fill_8_924 r0 *1 0,0
Xsky130_fd_sc_hd__fill_8_924 VSS VDD VDD sky130_fd_sc_hd__fill_8
* cell instance sky130_fd_sc_hd__fill_8_925 r0 *1 0,0
Xsky130_fd_sc_hd__fill_8_925 VSS VDD VDD sky130_fd_sc_hd__fill_8
* cell instance sky130_fd_sc_hd__fill_8_926 r0 *1 0,0
Xsky130_fd_sc_hd__fill_8_926 VSS VDD VDD sky130_fd_sc_hd__fill_8
* cell instance sky130_fd_sc_hd__fill_8_927 r0 *1 0,0
Xsky130_fd_sc_hd__fill_8_927 VSS VDD VDD sky130_fd_sc_hd__fill_8
* cell instance sky130_fd_sc_hd__fill_8_928 r0 *1 0,0
Xsky130_fd_sc_hd__fill_8_928 VSS VDD VDD sky130_fd_sc_hd__fill_8
* cell instance sky130_fd_sc_hd__fill_8_929 r0 *1 0,0
Xsky130_fd_sc_hd__fill_8_929 VSS VDD VDD sky130_fd_sc_hd__fill_8
* cell instance sky130_fd_sc_hd__fill_8_930 r0 *1 0,0
Xsky130_fd_sc_hd__fill_8_930 VSS VDD VDD sky130_fd_sc_hd__fill_8
* cell instance sky130_fd_sc_hd__fill_8_931 r0 *1 0,0
Xsky130_fd_sc_hd__fill_8_931 VSS VDD VDD sky130_fd_sc_hd__fill_8
* cell instance sky130_fd_sc_hd__fill_8_932 r0 *1 0,0
Xsky130_fd_sc_hd__fill_8_932 VSS VDD VDD sky130_fd_sc_hd__fill_8
* cell instance sky130_fd_sc_hd__fill_8_933 r0 *1 0,0
Xsky130_fd_sc_hd__fill_8_933 VSS VDD VDD sky130_fd_sc_hd__fill_8
* cell instance sky130_fd_sc_hd__fill_8_934 r0 *1 0,0
Xsky130_fd_sc_hd__fill_8_934 VSS VDD VDD sky130_fd_sc_hd__fill_8
* cell instance sky130_fd_sc_hd__fill_8_935 r0 *1 0,0
Xsky130_fd_sc_hd__fill_8_935 VSS VDD VDD sky130_fd_sc_hd__fill_8
* cell instance sky130_fd_sc_hd__fill_8_936 r0 *1 0,0
Xsky130_fd_sc_hd__fill_8_936 VSS VDD VDD sky130_fd_sc_hd__fill_8
* cell instance sky130_fd_sc_hd__fill_8_937 r0 *1 0,0
Xsky130_fd_sc_hd__fill_8_937 VSS VDD VDD sky130_fd_sc_hd__fill_8
* cell instance sky130_fd_sc_hd__fill_8_938 r0 *1 0,0
Xsky130_fd_sc_hd__fill_8_938 VSS VDD VDD sky130_fd_sc_hd__fill_8
* cell instance sky130_fd_sc_hd__fill_8_939 r0 *1 0,0
Xsky130_fd_sc_hd__fill_8_939 VSS VDD VDD sky130_fd_sc_hd__fill_8
* cell instance sky130_fd_sc_hd__fill_8_940 r0 *1 0,0
Xsky130_fd_sc_hd__fill_8_940 VSS VDD VDD sky130_fd_sc_hd__fill_8
* cell instance sky130_fd_sc_hd__fill_8_941 r0 *1 0,0
Xsky130_fd_sc_hd__fill_8_941 VSS VDD VDD sky130_fd_sc_hd__fill_8
* cell instance sky130_fd_sc_hd__fill_8_942 r0 *1 0,0
Xsky130_fd_sc_hd__fill_8_942 VSS VDD VDD sky130_fd_sc_hd__fill_8
* cell instance sky130_fd_sc_hd__fill_8_943 r0 *1 0,0
Xsky130_fd_sc_hd__fill_8_943 VSS VDD VDD sky130_fd_sc_hd__fill_8
* cell instance sky130_fd_sc_hd__fill_8_944 r0 *1 0,0
Xsky130_fd_sc_hd__fill_8_944 VSS VDD VDD sky130_fd_sc_hd__fill_8
* cell instance sky130_fd_sc_hd__fill_8_945 r0 *1 0,0
Xsky130_fd_sc_hd__fill_8_945 VSS VDD VDD sky130_fd_sc_hd__fill_8
* cell instance sky130_fd_sc_hd__fill_8_946 r0 *1 0,0
Xsky130_fd_sc_hd__fill_8_946 VSS VDD VDD sky130_fd_sc_hd__fill_8
* cell instance sky130_fd_sc_hd__fill_8_947 r0 *1 0,0
Xsky130_fd_sc_hd__fill_8_947 VSS VDD VDD sky130_fd_sc_hd__fill_8
* cell instance sky130_fd_sc_hd__fill_8_948 r0 *1 0,0
Xsky130_fd_sc_hd__fill_8_948 VSS VDD VDD sky130_fd_sc_hd__fill_8
* cell instance sky130_fd_sc_hd__fill_8_949 r0 *1 0,0
Xsky130_fd_sc_hd__fill_8_949 VSS VDD VDD sky130_fd_sc_hd__fill_8
* cell instance sky130_fd_sc_hd__fill_8_950 r0 *1 0,0
Xsky130_fd_sc_hd__fill_8_950 VSS VDD VDD sky130_fd_sc_hd__fill_8
* cell instance sky130_fd_sc_hd__fill_8_951 r0 *1 0,0
Xsky130_fd_sc_hd__fill_8_951 VSS VDD VDD sky130_fd_sc_hd__fill_8
* cell instance sky130_fd_sc_hd__fill_8_952 r0 *1 0,0
Xsky130_fd_sc_hd__fill_8_952 VSS VDD VDD sky130_fd_sc_hd__fill_8
* cell instance sky130_fd_sc_hd__fill_8_953 r0 *1 0,0
Xsky130_fd_sc_hd__fill_8_953 VSS VDD VDD sky130_fd_sc_hd__fill_8
* cell instance sky130_fd_sc_hd__fill_8_954 r0 *1 0,0
Xsky130_fd_sc_hd__fill_8_954 VSS VDD VDD sky130_fd_sc_hd__fill_8
* cell instance sky130_fd_sc_hd__fill_8_955 r0 *1 0,0
Xsky130_fd_sc_hd__fill_8_955 VSS VDD VDD sky130_fd_sc_hd__fill_8
* cell instance sky130_fd_sc_hd__fill_8_956 r0 *1 0,0
Xsky130_fd_sc_hd__fill_8_956 VSS VDD VDD sky130_fd_sc_hd__fill_8
* cell instance sky130_fd_sc_hd__fill_8_957 r0 *1 0,0
Xsky130_fd_sc_hd__fill_8_957 VSS VDD VDD sky130_fd_sc_hd__fill_8
* cell instance sky130_fd_sc_hd__fill_8_958 r0 *1 0,0
Xsky130_fd_sc_hd__fill_8_958 VSS VDD VDD sky130_fd_sc_hd__fill_8
* cell instance sky130_fd_sc_hd__fill_8_959 r0 *1 0,0
Xsky130_fd_sc_hd__fill_8_959 VSS VDD VDD sky130_fd_sc_hd__fill_8
* cell instance sky130_fd_sc_hd__fill_8_960 r0 *1 0,0
Xsky130_fd_sc_hd__fill_8_960 VSS VDD VDD sky130_fd_sc_hd__fill_8
* cell instance sky130_fd_sc_hd__fill_8_961 r0 *1 0,0
Xsky130_fd_sc_hd__fill_8_961 VSS VDD VDD sky130_fd_sc_hd__fill_8
* cell instance sky130_fd_sc_hd__fill_8_962 r0 *1 0,0
Xsky130_fd_sc_hd__fill_8_962 VSS VDD VDD sky130_fd_sc_hd__fill_8
* cell instance sky130_fd_sc_hd__fill_8_963 r0 *1 0,0
Xsky130_fd_sc_hd__fill_8_963 VSS VDD VDD sky130_fd_sc_hd__fill_8
* cell instance sky130_fd_sc_hd__fill_8_964 r0 *1 0,0
Xsky130_fd_sc_hd__fill_8_964 VSS VDD VDD sky130_fd_sc_hd__fill_8
* cell instance sky130_fd_sc_hd__fill_8_965 r0 *1 0,0
Xsky130_fd_sc_hd__fill_8_965 VSS VDD VDD sky130_fd_sc_hd__fill_8
* cell instance sky130_fd_sc_hd__fill_8_966 r0 *1 0,0
Xsky130_fd_sc_hd__fill_8_966 VSS VDD VDD sky130_fd_sc_hd__fill_8
* cell instance sky130_fd_sc_hd__fill_8_967 r0 *1 0,0
Xsky130_fd_sc_hd__fill_8_967 VSS VDD VDD sky130_fd_sc_hd__fill_8
* cell instance sky130_fd_sc_hd__fill_8_968 r0 *1 0,0
Xsky130_fd_sc_hd__fill_8_968 VSS VDD VDD sky130_fd_sc_hd__fill_8
* cell instance sky130_fd_sc_hd__fill_8_969 r0 *1 0,0
Xsky130_fd_sc_hd__fill_8_969 VSS VDD VDD sky130_fd_sc_hd__fill_8
* cell instance sky130_fd_sc_hd__fill_8_970 r0 *1 0,0
Xsky130_fd_sc_hd__fill_8_970 VSS VDD VDD sky130_fd_sc_hd__fill_8
* cell instance sky130_fd_sc_hd__fill_8_971 r0 *1 0,0
Xsky130_fd_sc_hd__fill_8_971 VSS VDD VDD sky130_fd_sc_hd__fill_8
* cell instance sky130_fd_sc_hd__fill_8_972 r0 *1 0,0
Xsky130_fd_sc_hd__fill_8_972 VSS VDD VDD sky130_fd_sc_hd__fill_8
* cell instance sky130_fd_sc_hd__fill_8_973 r0 *1 0,0
Xsky130_fd_sc_hd__fill_8_973 VSS VDD VDD sky130_fd_sc_hd__fill_8
* cell instance sky130_fd_sc_hd__fill_8_974 r0 *1 0,0
Xsky130_fd_sc_hd__fill_8_974 VSS VDD VDD sky130_fd_sc_hd__fill_8
* cell instance sky130_fd_sc_hd__fill_8_975 r0 *1 0,0
Xsky130_fd_sc_hd__fill_8_975 VSS VDD VDD sky130_fd_sc_hd__fill_8
* cell instance sky130_fd_sc_hd__fill_8_976 r0 *1 0,0
Xsky130_fd_sc_hd__fill_8_976 VSS VDD VDD sky130_fd_sc_hd__fill_8
* cell instance sky130_fd_sc_hd__fill_8_977 r0 *1 0,0
Xsky130_fd_sc_hd__fill_8_977 VSS VDD VDD sky130_fd_sc_hd__fill_8
* cell instance sky130_fd_sc_hd__fill_8_978 r0 *1 0,0
Xsky130_fd_sc_hd__fill_8_978 VSS VDD VDD sky130_fd_sc_hd__fill_8
* cell instance sky130_fd_sc_hd__fill_8_979 r0 *1 0,0
Xsky130_fd_sc_hd__fill_8_979 VSS VDD VDD sky130_fd_sc_hd__fill_8
* cell instance sky130_fd_sc_hd__fill_8_980 r0 *1 0,0
Xsky130_fd_sc_hd__fill_8_980 VSS VDD VDD sky130_fd_sc_hd__fill_8
* cell instance sky130_fd_sc_hd__fill_8_981 r0 *1 0,0
Xsky130_fd_sc_hd__fill_8_981 VSS VDD VDD sky130_fd_sc_hd__fill_8
* cell instance sky130_fd_sc_hd__fill_8_982 r0 *1 0,0
Xsky130_fd_sc_hd__fill_8_982 VSS VDD VDD sky130_fd_sc_hd__fill_8
* cell instance sky130_fd_sc_hd__fill_8_983 r0 *1 0,0
Xsky130_fd_sc_hd__fill_8_983 VSS VDD VDD sky130_fd_sc_hd__fill_8
* cell instance sky130_fd_sc_hd__fill_8_984 r0 *1 0,0
Xsky130_fd_sc_hd__fill_8_984 VSS VDD VDD sky130_fd_sc_hd__fill_8
* cell instance sky130_fd_sc_hd__fill_8_985 r0 *1 0,0
Xsky130_fd_sc_hd__fill_8_985 VSS VDD VDD sky130_fd_sc_hd__fill_8
* cell instance sky130_fd_sc_hd__fill_8_986 r0 *1 0,0
Xsky130_fd_sc_hd__fill_8_986 VSS VDD VDD sky130_fd_sc_hd__fill_8
* cell instance sky130_fd_sc_hd__fill_8_987 r0 *1 0,0
Xsky130_fd_sc_hd__fill_8_987 VSS VDD VDD sky130_fd_sc_hd__fill_8
* cell instance sky130_fd_sc_hd__fill_8_988 r0 *1 0,0
Xsky130_fd_sc_hd__fill_8_988 VSS VDD VDD sky130_fd_sc_hd__fill_8
* cell instance sky130_fd_sc_hd__fill_8_989 r0 *1 0,0
Xsky130_fd_sc_hd__fill_8_989 VSS VDD VDD sky130_fd_sc_hd__fill_8
* cell instance sky130_fd_sc_hd__fill_8_990 r0 *1 0,0
Xsky130_fd_sc_hd__fill_8_990 VSS VDD VDD sky130_fd_sc_hd__fill_8
* cell instance sky130_fd_sc_hd__fill_8_991 r0 *1 0,0
Xsky130_fd_sc_hd__fill_8_991 VSS VDD VDD sky130_fd_sc_hd__fill_8
* cell instance sky130_fd_sc_hd__fill_8_992 r0 *1 0,0
Xsky130_fd_sc_hd__fill_8_992 VSS VDD VDD sky130_fd_sc_hd__fill_8
* cell instance sky130_fd_sc_hd__fill_8_993 r0 *1 0,0
Xsky130_fd_sc_hd__fill_8_993 VSS VDD VDD sky130_fd_sc_hd__fill_8
* cell instance sky130_fd_sc_hd__fill_8_994 r0 *1 0,0
Xsky130_fd_sc_hd__fill_8_994 VSS VDD VDD sky130_fd_sc_hd__fill_8
* cell instance sky130_fd_sc_hd__fill_8_995 r0 *1 0,0
Xsky130_fd_sc_hd__fill_8_995 VSS VDD VDD sky130_fd_sc_hd__fill_8
* cell instance sky130_fd_sc_hd__fill_8_996 r0 *1 0,0
Xsky130_fd_sc_hd__fill_8_996 VSS VDD VDD sky130_fd_sc_hd__fill_8
* cell instance sky130_fd_sc_hd__fill_8_997 r0 *1 0,0
Xsky130_fd_sc_hd__fill_8_997 VSS VDD VDD sky130_fd_sc_hd__fill_8
* cell instance sky130_fd_sc_hd__fill_8_998 r0 *1 0,0
Xsky130_fd_sc_hd__fill_8_998 VSS VDD VDD sky130_fd_sc_hd__fill_8
* cell instance sky130_fd_sc_hd__fill_8_999 r0 *1 0,0
Xsky130_fd_sc_hd__fill_8_999 VSS VDD VDD sky130_fd_sc_hd__fill_8
* cell instance sky130_fd_sc_hd__fill_8_1000 r0 *1 0,0
Xsky130_fd_sc_hd__fill_8_1000 VSS VDD VDD sky130_fd_sc_hd__fill_8
* cell instance sky130_fd_sc_hd__fill_8_1001 r0 *1 0,0
Xsky130_fd_sc_hd__fill_8_1001 VSS VDD VDD sky130_fd_sc_hd__fill_8
* cell instance sky130_fd_sc_hd__fill_8_1002 r0 *1 0,0
Xsky130_fd_sc_hd__fill_8_1002 VSS VDD VDD sky130_fd_sc_hd__fill_8
* cell instance sky130_fd_sc_hd__fill_8_1003 r0 *1 0,0
Xsky130_fd_sc_hd__fill_8_1003 VSS VDD VDD sky130_fd_sc_hd__fill_8
* cell instance sky130_fd_sc_hd__fill_8_1004 r0 *1 0,0
Xsky130_fd_sc_hd__fill_8_1004 VSS VDD VDD sky130_fd_sc_hd__fill_8
* cell instance sky130_fd_sc_hd__fill_8_1005 r0 *1 0,0
Xsky130_fd_sc_hd__fill_8_1005 VSS VDD VDD sky130_fd_sc_hd__fill_8
* cell instance sky130_fd_sc_hd__fill_8_1006 r0 *1 0,0
Xsky130_fd_sc_hd__fill_8_1006 VSS VDD VDD sky130_fd_sc_hd__fill_8
* cell instance sky130_fd_sc_hd__fill_8_1007 r0 *1 0,0
Xsky130_fd_sc_hd__fill_8_1007 VSS VDD VDD sky130_fd_sc_hd__fill_8
* cell instance sky130_fd_sc_hd__fill_8_1008 r0 *1 0,0
Xsky130_fd_sc_hd__fill_8_1008 VSS VDD VDD sky130_fd_sc_hd__fill_8
* cell instance sky130_fd_sc_hd__fill_8_1009 r0 *1 0,0
Xsky130_fd_sc_hd__fill_8_1009 VSS VDD VDD sky130_fd_sc_hd__fill_8
* cell instance sky130_fd_sc_hd__fill_8_1010 r0 *1 0,0
Xsky130_fd_sc_hd__fill_8_1010 VSS VDD VDD sky130_fd_sc_hd__fill_8
* cell instance sky130_fd_sc_hd__fill_8_1011 r0 *1 0,0
Xsky130_fd_sc_hd__fill_8_1011 VSS VDD VDD sky130_fd_sc_hd__fill_8
* cell instance sky130_fd_sc_hd__fill_8_1012 r0 *1 0,0
Xsky130_fd_sc_hd__fill_8_1012 VSS VDD VDD sky130_fd_sc_hd__fill_8
* cell instance sky130_fd_sc_hd__fill_8_1013 r0 *1 0,0
Xsky130_fd_sc_hd__fill_8_1013 VSS VDD VDD sky130_fd_sc_hd__fill_8
* cell instance sky130_fd_sc_hd__fill_8_1014 r0 *1 0,0
Xsky130_fd_sc_hd__fill_8_1014 VSS VDD VDD sky130_fd_sc_hd__fill_8
* cell instance sky130_fd_sc_hd__fill_8_1015 r0 *1 0,0
Xsky130_fd_sc_hd__fill_8_1015 VSS VDD VDD sky130_fd_sc_hd__fill_8
* cell instance sky130_fd_sc_hd__fill_8_1016 r0 *1 0,0
Xsky130_fd_sc_hd__fill_8_1016 VSS VDD VDD sky130_fd_sc_hd__fill_8
* cell instance sky130_fd_sc_hd__fill_8_1017 r0 *1 0,0
Xsky130_fd_sc_hd__fill_8_1017 VSS VDD VDD sky130_fd_sc_hd__fill_8
* cell instance sky130_fd_sc_hd__fill_8_1018 r0 *1 0,0
Xsky130_fd_sc_hd__fill_8_1018 VSS VDD VDD sky130_fd_sc_hd__fill_8
* cell instance sky130_fd_sc_hd__fill_8_1019 r0 *1 0,0
Xsky130_fd_sc_hd__fill_8_1019 VSS VDD VDD sky130_fd_sc_hd__fill_8
* cell instance sky130_fd_sc_hd__fill_8_1020 r0 *1 0,0
Xsky130_fd_sc_hd__fill_8_1020 VSS VDD VDD sky130_fd_sc_hd__fill_8
* cell instance sky130_fd_sc_hd__fill_8_1021 r0 *1 0,0
Xsky130_fd_sc_hd__fill_8_1021 VSS VDD VDD sky130_fd_sc_hd__fill_8
* cell instance sky130_fd_sc_hd__fill_8_1022 r0 *1 0,0
Xsky130_fd_sc_hd__fill_8_1022 VSS VDD VDD sky130_fd_sc_hd__fill_8
* cell instance sky130_fd_sc_hd__fill_8_1023 r0 *1 0,0
Xsky130_fd_sc_hd__fill_8_1023 VSS VDD VDD sky130_fd_sc_hd__fill_8
* cell instance sky130_fd_sc_hd__fill_8_1024 r0 *1 0,0
Xsky130_fd_sc_hd__fill_8_1024 VSS VDD VDD sky130_fd_sc_hd__fill_8
* cell instance sky130_fd_sc_hd__fill_8_1025 r0 *1 0,0
Xsky130_fd_sc_hd__fill_8_1025 VSS VDD VDD sky130_fd_sc_hd__fill_8
* cell instance sky130_fd_sc_hd__fill_8_1026 r0 *1 0,0
Xsky130_fd_sc_hd__fill_8_1026 VSS VDD VDD sky130_fd_sc_hd__fill_8
* cell instance sky130_fd_sc_hd__fill_8_1027 r0 *1 0,0
Xsky130_fd_sc_hd__fill_8_1027 VSS VDD VDD sky130_fd_sc_hd__fill_8
* cell instance sky130_fd_sc_hd__fill_8_1028 r0 *1 0,0
Xsky130_fd_sc_hd__fill_8_1028 VSS VDD VDD sky130_fd_sc_hd__fill_8
* cell instance sky130_fd_sc_hd__fill_8_1029 r0 *1 0,0
Xsky130_fd_sc_hd__fill_8_1029 VSS VDD VDD sky130_fd_sc_hd__fill_8
* cell instance sky130_fd_sc_hd__fill_8_1030 r0 *1 0,0
Xsky130_fd_sc_hd__fill_8_1030 VSS VDD VDD sky130_fd_sc_hd__fill_8
* cell instance sky130_fd_sc_hd__fill_8_1031 r0 *1 0,0
Xsky130_fd_sc_hd__fill_8_1031 VSS VDD VDD sky130_fd_sc_hd__fill_8
* cell instance sky130_fd_sc_hd__fill_8_1032 r0 *1 0,0
Xsky130_fd_sc_hd__fill_8_1032 VSS VDD VDD sky130_fd_sc_hd__fill_8
* cell instance sky130_fd_sc_hd__fill_8_1033 r0 *1 0,0
Xsky130_fd_sc_hd__fill_8_1033 VSS VDD VDD sky130_fd_sc_hd__fill_8
* cell instance sky130_fd_sc_hd__fill_8_1034 r0 *1 0,0
Xsky130_fd_sc_hd__fill_8_1034 VSS VDD VDD sky130_fd_sc_hd__fill_8
* cell instance sky130_fd_sc_hd__fill_8_1035 r0 *1 0,0
Xsky130_fd_sc_hd__fill_8_1035 VSS VDD VDD sky130_fd_sc_hd__fill_8
* cell instance sky130_fd_sc_hd__fill_8_1036 r0 *1 0,0
Xsky130_fd_sc_hd__fill_8_1036 VSS VDD VDD sky130_fd_sc_hd__fill_8
* cell instance sky130_fd_sc_hd__fill_8_1037 r0 *1 0,0
Xsky130_fd_sc_hd__fill_8_1037 VSS VDD VDD sky130_fd_sc_hd__fill_8
* cell instance sky130_fd_sc_hd__fill_8_1038 r0 *1 0,0
Xsky130_fd_sc_hd__fill_8_1038 VSS VDD VDD sky130_fd_sc_hd__fill_8
* cell instance sky130_fd_sc_hd__fill_8_1039 r0 *1 0,0
Xsky130_fd_sc_hd__fill_8_1039 VSS VDD VDD sky130_fd_sc_hd__fill_8
* cell instance sky130_fd_sc_hd__fill_8_1040 r0 *1 0,0
Xsky130_fd_sc_hd__fill_8_1040 VSS VDD VDD sky130_fd_sc_hd__fill_8
* cell instance sky130_fd_sc_hd__fill_8_1041 r0 *1 0,0
Xsky130_fd_sc_hd__fill_8_1041 VSS VDD VDD sky130_fd_sc_hd__fill_8
* cell instance sky130_fd_sc_hd__fill_8_1042 r0 *1 0,0
Xsky130_fd_sc_hd__fill_8_1042 VSS VDD VDD sky130_fd_sc_hd__fill_8
* cell instance sky130_fd_sc_hd__fill_8_1043 r0 *1 0,0
Xsky130_fd_sc_hd__fill_8_1043 VSS VDD VDD sky130_fd_sc_hd__fill_8
* cell instance sky130_fd_sc_hd__fill_8_1044 r0 *1 0,0
Xsky130_fd_sc_hd__fill_8_1044 VSS VDD VDD sky130_fd_sc_hd__fill_8
* cell instance sky130_fd_sc_hd__fill_8_1045 r0 *1 0,0
Xsky130_fd_sc_hd__fill_8_1045 VSS VDD VDD sky130_fd_sc_hd__fill_8
* cell instance sky130_fd_sc_hd__fill_8_1046 r0 *1 0,0
Xsky130_fd_sc_hd__fill_8_1046 VSS VDD VDD sky130_fd_sc_hd__fill_8
* cell instance sky130_fd_sc_hd__fill_8_1047 r0 *1 0,0
Xsky130_fd_sc_hd__fill_8_1047 VSS VDD VDD sky130_fd_sc_hd__fill_8
* cell instance sky130_fd_sc_hd__fill_8_1048 r0 *1 0,0
Xsky130_fd_sc_hd__fill_8_1048 VSS VDD VDD sky130_fd_sc_hd__fill_8
* cell instance sky130_fd_sc_hd__fill_8_1049 r0 *1 0,0
Xsky130_fd_sc_hd__fill_8_1049 VSS VDD VDD sky130_fd_sc_hd__fill_8
* cell instance sky130_fd_sc_hd__fill_8_1050 r0 *1 0,0
Xsky130_fd_sc_hd__fill_8_1050 VSS VDD VDD sky130_fd_sc_hd__fill_8
* cell instance sky130_fd_sc_hd__fill_8_1051 r0 *1 0,0
Xsky130_fd_sc_hd__fill_8_1051 VSS VDD VDD sky130_fd_sc_hd__fill_8
* cell instance sky130_fd_sc_hd__fill_8_1052 r0 *1 0,0
Xsky130_fd_sc_hd__fill_8_1052 VSS VDD VDD sky130_fd_sc_hd__fill_8
* cell instance sky130_fd_sc_hd__fill_8_1053 r0 *1 0,0
Xsky130_fd_sc_hd__fill_8_1053 VSS VDD VDD sky130_fd_sc_hd__fill_8
* cell instance sky130_fd_sc_hd__fill_8_1054 r0 *1 0,0
Xsky130_fd_sc_hd__fill_8_1054 VSS VDD VDD sky130_fd_sc_hd__fill_8
* cell instance sky130_fd_sc_hd__fill_8_1055 r0 *1 0,0
Xsky130_fd_sc_hd__fill_8_1055 VSS VDD VDD sky130_fd_sc_hd__fill_8
* cell instance sky130_fd_sc_hd__fill_8_1056 r0 *1 0,0
Xsky130_fd_sc_hd__fill_8_1056 VSS VDD VDD sky130_fd_sc_hd__fill_8
* cell instance sky130_fd_sc_hd__fill_8_1057 r0 *1 0,0
Xsky130_fd_sc_hd__fill_8_1057 VSS VDD VDD sky130_fd_sc_hd__fill_8
* cell instance sky130_fd_sc_hd__fill_8_1058 r0 *1 0,0
Xsky130_fd_sc_hd__fill_8_1058 VSS VDD VDD sky130_fd_sc_hd__fill_8
* cell instance sky130_fd_sc_hd__fill_8_1059 r0 *1 0,0
Xsky130_fd_sc_hd__fill_8_1059 VSS VDD VDD sky130_fd_sc_hd__fill_8
* cell instance sky130_fd_sc_hd__fill_8_1060 r0 *1 0,0
Xsky130_fd_sc_hd__fill_8_1060 VSS VDD VDD sky130_fd_sc_hd__fill_8
* cell instance sky130_fd_sc_hd__fill_8_1061 r0 *1 0,0
Xsky130_fd_sc_hd__fill_8_1061 VSS VDD VDD sky130_fd_sc_hd__fill_8
* cell instance sky130_fd_sc_hd__fill_8_1062 r0 *1 0,0
Xsky130_fd_sc_hd__fill_8_1062 VSS VDD VDD sky130_fd_sc_hd__fill_8
* cell instance sky130_fd_sc_hd__fill_8_1063 r0 *1 0,0
Xsky130_fd_sc_hd__fill_8_1063 VSS VDD VDD sky130_fd_sc_hd__fill_8
* cell instance sky130_fd_sc_hd__fill_8_1064 r0 *1 0,0
Xsky130_fd_sc_hd__fill_8_1064 VSS VDD VDD sky130_fd_sc_hd__fill_8
* cell instance sky130_fd_sc_hd__fill_8_1065 r0 *1 0,0
Xsky130_fd_sc_hd__fill_8_1065 VSS VDD VDD sky130_fd_sc_hd__fill_8
* cell instance sky130_fd_sc_hd__fill_8_1066 r0 *1 0,0
Xsky130_fd_sc_hd__fill_8_1066 VSS VDD VDD sky130_fd_sc_hd__fill_8
* cell instance sky130_fd_sc_hd__fill_8_1067 r0 *1 0,0
Xsky130_fd_sc_hd__fill_8_1067 VSS VDD VDD sky130_fd_sc_hd__fill_8
* cell instance sky130_fd_sc_hd__fill_8_1068 r0 *1 0,0
Xsky130_fd_sc_hd__fill_8_1068 VSS VDD VDD sky130_fd_sc_hd__fill_8
* cell instance sky130_fd_sc_hd__fill_8_1069 r0 *1 0,0
Xsky130_fd_sc_hd__fill_8_1069 VSS VDD VDD sky130_fd_sc_hd__fill_8
* cell instance sky130_fd_sc_hd__fill_8_1070 r0 *1 0,0
Xsky130_fd_sc_hd__fill_8_1070 VSS VDD VDD sky130_fd_sc_hd__fill_8
* cell instance sky130_fd_sc_hd__fill_8_1071 r0 *1 0,0
Xsky130_fd_sc_hd__fill_8_1071 VSS VDD VDD sky130_fd_sc_hd__fill_8
* cell instance sky130_fd_sc_hd__fill_8_1072 r0 *1 0,0
Xsky130_fd_sc_hd__fill_8_1072 VSS VDD VDD sky130_fd_sc_hd__fill_8
* cell instance sky130_fd_sc_hd__fill_8_1073 r0 *1 0,0
Xsky130_fd_sc_hd__fill_8_1073 VSS VDD VDD sky130_fd_sc_hd__fill_8
* cell instance sky130_fd_sc_hd__fill_8_1074 r0 *1 0,0
Xsky130_fd_sc_hd__fill_8_1074 VSS VDD VDD sky130_fd_sc_hd__fill_8
* cell instance sky130_fd_sc_hd__fill_8_1075 r0 *1 0,0
Xsky130_fd_sc_hd__fill_8_1075 VSS VDD VDD sky130_fd_sc_hd__fill_8
* cell instance sky130_fd_sc_hd__fill_8_1076 r0 *1 0,0
Xsky130_fd_sc_hd__fill_8_1076 VSS VDD VDD sky130_fd_sc_hd__fill_8
* cell instance sky130_fd_sc_hd__fill_8_1077 r0 *1 0,0
Xsky130_fd_sc_hd__fill_8_1077 VSS VDD VDD sky130_fd_sc_hd__fill_8
* cell instance sky130_fd_sc_hd__fill_8_1078 r0 *1 0,0
Xsky130_fd_sc_hd__fill_8_1078 VSS VDD VDD sky130_fd_sc_hd__fill_8
* cell instance sky130_fd_sc_hd__fill_8_1079 r0 *1 0,0
Xsky130_fd_sc_hd__fill_8_1079 VSS VDD VDD sky130_fd_sc_hd__fill_8
* cell instance sky130_fd_sc_hd__fill_8_1080 r0 *1 0,0
Xsky130_fd_sc_hd__fill_8_1080 VSS VDD VDD sky130_fd_sc_hd__fill_8
* cell instance sky130_fd_sc_hd__fill_8_1081 r0 *1 0,0
Xsky130_fd_sc_hd__fill_8_1081 VSS VDD VDD sky130_fd_sc_hd__fill_8
* cell instance sky130_fd_sc_hd__fill_8_1082 r0 *1 0,0
Xsky130_fd_sc_hd__fill_8_1082 VSS VDD VDD sky130_fd_sc_hd__fill_8
* cell instance sky130_fd_sc_hd__fill_8_1083 r0 *1 0,0
Xsky130_fd_sc_hd__fill_8_1083 VSS VDD VDD sky130_fd_sc_hd__fill_8
* cell instance sky130_fd_sc_hd__fill_8_1084 r0 *1 0,0
Xsky130_fd_sc_hd__fill_8_1084 VSS VDD VDD sky130_fd_sc_hd__fill_8
* cell instance sky130_fd_sc_hd__fill_8_1085 r0 *1 0,0
Xsky130_fd_sc_hd__fill_8_1085 VSS VDD VDD sky130_fd_sc_hd__fill_8
* cell instance sky130_fd_sc_hd__fill_8_1086 r0 *1 0,0
Xsky130_fd_sc_hd__fill_8_1086 VSS VDD VDD sky130_fd_sc_hd__fill_8
* cell instance sky130_fd_sc_hd__fill_8_1087 r0 *1 0,0
Xsky130_fd_sc_hd__fill_8_1087 VSS VDD VDD sky130_fd_sc_hd__fill_8
* cell instance sky130_fd_sc_hd__fill_8_1088 r0 *1 0,0
Xsky130_fd_sc_hd__fill_8_1088 VSS VDD VDD sky130_fd_sc_hd__fill_8
* cell instance sky130_fd_sc_hd__fill_8_1089 r0 *1 0,0
Xsky130_fd_sc_hd__fill_8_1089 VSS VDD VDD sky130_fd_sc_hd__fill_8
* cell instance sky130_fd_sc_hd__fill_8_1090 r0 *1 0,0
Xsky130_fd_sc_hd__fill_8_1090 VSS VDD VDD sky130_fd_sc_hd__fill_8
* cell instance sky130_fd_sc_hd__fill_8_1091 r0 *1 0,0
Xsky130_fd_sc_hd__fill_8_1091 VSS VDD VDD sky130_fd_sc_hd__fill_8
* cell instance sky130_fd_sc_hd__fill_8_1092 r0 *1 0,0
Xsky130_fd_sc_hd__fill_8_1092 VSS VDD VDD sky130_fd_sc_hd__fill_8
* cell instance sky130_fd_sc_hd__fill_8_1093 r0 *1 0,0
Xsky130_fd_sc_hd__fill_8_1093 VSS VDD VDD sky130_fd_sc_hd__fill_8
* cell instance sky130_fd_sc_hd__fill_8_1094 r0 *1 0,0
Xsky130_fd_sc_hd__fill_8_1094 VSS VDD VDD sky130_fd_sc_hd__fill_8
* cell instance sky130_fd_sc_hd__fill_8_1095 r0 *1 0,0
Xsky130_fd_sc_hd__fill_8_1095 VSS VDD VDD sky130_fd_sc_hd__fill_8
* cell instance sky130_fd_sc_hd__fill_8_1096 r0 *1 0,0
Xsky130_fd_sc_hd__fill_8_1096 VSS VDD VDD sky130_fd_sc_hd__fill_8
* cell instance sky130_fd_sc_hd__fill_8_1097 r0 *1 0,0
Xsky130_fd_sc_hd__fill_8_1097 VSS VDD VDD sky130_fd_sc_hd__fill_8
* cell instance sky130_fd_sc_hd__fill_8_1098 r0 *1 0,0
Xsky130_fd_sc_hd__fill_8_1098 VSS VDD VDD sky130_fd_sc_hd__fill_8
* cell instance sky130_fd_sc_hd__fill_8_1099 r0 *1 0,0
Xsky130_fd_sc_hd__fill_8_1099 VSS VDD VDD sky130_fd_sc_hd__fill_8
* cell instance sky130_fd_sc_hd__fill_8_1100 r0 *1 0,0
Xsky130_fd_sc_hd__fill_8_1100 VSS VDD VDD sky130_fd_sc_hd__fill_8
* cell instance sky130_fd_sc_hd__fill_8_1101 r0 *1 0,0
Xsky130_fd_sc_hd__fill_8_1101 VSS VDD VDD sky130_fd_sc_hd__fill_8
* cell instance sky130_fd_sc_hd__fill_8_1102 r0 *1 0,0
Xsky130_fd_sc_hd__fill_8_1102 VSS VDD VDD sky130_fd_sc_hd__fill_8
* cell instance sky130_fd_sc_hd__fill_8_1103 r0 *1 0,0
Xsky130_fd_sc_hd__fill_8_1103 VSS VDD VDD sky130_fd_sc_hd__fill_8
* cell instance sky130_fd_sc_hd__fill_8_1104 r0 *1 0,0
Xsky130_fd_sc_hd__fill_8_1104 VSS VDD VDD sky130_fd_sc_hd__fill_8
* cell instance sky130_fd_sc_hd__fill_8_1105 r0 *1 0,0
Xsky130_fd_sc_hd__fill_8_1105 VSS VDD VDD sky130_fd_sc_hd__fill_8
* cell instance sky130_fd_sc_hd__fill_8_1106 r0 *1 0,0
Xsky130_fd_sc_hd__fill_8_1106 VSS VDD VDD sky130_fd_sc_hd__fill_8
* cell instance sky130_fd_sc_hd__fill_8_1107 r0 *1 0,0
Xsky130_fd_sc_hd__fill_8_1107 VSS VDD VDD sky130_fd_sc_hd__fill_8
* cell instance sky130_fd_sc_hd__fill_8_1108 r0 *1 0,0
Xsky130_fd_sc_hd__fill_8_1108 VSS VDD VDD sky130_fd_sc_hd__fill_8
* cell instance sky130_fd_sc_hd__fill_8_1109 r0 *1 0,0
Xsky130_fd_sc_hd__fill_8_1109 VSS VDD VDD sky130_fd_sc_hd__fill_8
* cell instance sky130_fd_sc_hd__fill_8_1110 r0 *1 0,0
Xsky130_fd_sc_hd__fill_8_1110 VSS VDD VDD sky130_fd_sc_hd__fill_8
* cell instance sky130_fd_sc_hd__fill_8_1111 r0 *1 0,0
Xsky130_fd_sc_hd__fill_8_1111 VSS VDD VDD sky130_fd_sc_hd__fill_8
* cell instance sky130_fd_sc_hd__fill_8_1112 r0 *1 0,0
Xsky130_fd_sc_hd__fill_8_1112 VSS VDD VDD sky130_fd_sc_hd__fill_8
* cell instance sky130_fd_sc_hd__fill_8_1113 r0 *1 0,0
Xsky130_fd_sc_hd__fill_8_1113 VSS VDD VDD sky130_fd_sc_hd__fill_8
* cell instance sky130_fd_sc_hd__fill_8_1114 r0 *1 0,0
Xsky130_fd_sc_hd__fill_8_1114 VSS VDD VDD sky130_fd_sc_hd__fill_8
* cell instance sky130_fd_sc_hd__fill_8_1115 r0 *1 0,0
Xsky130_fd_sc_hd__fill_8_1115 VSS VDD VDD sky130_fd_sc_hd__fill_8
* cell instance sky130_fd_sc_hd__fill_8_1116 r0 *1 0,0
Xsky130_fd_sc_hd__fill_8_1116 VSS VDD VDD sky130_fd_sc_hd__fill_8
* cell instance sky130_fd_sc_hd__fill_8_1117 r0 *1 0,0
Xsky130_fd_sc_hd__fill_8_1117 VSS VDD VDD sky130_fd_sc_hd__fill_8
* cell instance sky130_fd_sc_hd__fill_8_1118 r0 *1 0,0
Xsky130_fd_sc_hd__fill_8_1118 VSS VDD VDD sky130_fd_sc_hd__fill_8
* cell instance sky130_fd_sc_hd__fill_8_1119 r0 *1 0,0
Xsky130_fd_sc_hd__fill_8_1119 VSS VDD VDD sky130_fd_sc_hd__fill_8
* cell instance sky130_fd_sc_hd__fill_8_1120 r0 *1 0,0
Xsky130_fd_sc_hd__fill_8_1120 VSS VDD VDD sky130_fd_sc_hd__fill_8
* cell instance sky130_fd_sc_hd__fill_8_1121 r0 *1 0,0
Xsky130_fd_sc_hd__fill_8_1121 VSS VDD VDD sky130_fd_sc_hd__fill_8
* cell instance sky130_fd_sc_hd__fill_8_1122 r0 *1 0,0
Xsky130_fd_sc_hd__fill_8_1122 VSS VDD VDD sky130_fd_sc_hd__fill_8
* cell instance sky130_fd_sc_hd__fill_8_1123 r0 *1 0,0
Xsky130_fd_sc_hd__fill_8_1123 VSS VDD VDD sky130_fd_sc_hd__fill_8
* cell instance sky130_fd_sc_hd__fill_8_1124 r0 *1 0,0
Xsky130_fd_sc_hd__fill_8_1124 VSS VDD VDD sky130_fd_sc_hd__fill_8
* cell instance sky130_fd_sc_hd__fill_8_1125 r0 *1 0,0
Xsky130_fd_sc_hd__fill_8_1125 VSS VDD VDD sky130_fd_sc_hd__fill_8
* cell instance sky130_fd_sc_hd__fill_8_1126 r0 *1 0,0
Xsky130_fd_sc_hd__fill_8_1126 VSS VDD VDD sky130_fd_sc_hd__fill_8
* cell instance sky130_fd_sc_hd__fill_8_1127 r0 *1 0,0
Xsky130_fd_sc_hd__fill_8_1127 VSS VDD VDD sky130_fd_sc_hd__fill_8
* cell instance sky130_fd_sc_hd__fill_8_1128 r0 *1 0,0
Xsky130_fd_sc_hd__fill_8_1128 VSS VDD VDD sky130_fd_sc_hd__fill_8
* cell instance sky130_fd_sc_hd__fill_8_1129 r0 *1 0,0
Xsky130_fd_sc_hd__fill_8_1129 VSS VDD VDD sky130_fd_sc_hd__fill_8
* cell instance sky130_fd_sc_hd__fill_8_1130 r0 *1 0,0
Xsky130_fd_sc_hd__fill_8_1130 VSS VDD VDD sky130_fd_sc_hd__fill_8
* cell instance sky130_fd_sc_hd__fill_8_1131 r0 *1 0,0
Xsky130_fd_sc_hd__fill_8_1131 VSS VDD VDD sky130_fd_sc_hd__fill_8
* cell instance sky130_fd_sc_hd__fill_8_1132 r0 *1 0,0
Xsky130_fd_sc_hd__fill_8_1132 VSS VDD VDD sky130_fd_sc_hd__fill_8
* cell instance sky130_fd_sc_hd__fill_8_1133 r0 *1 0,0
Xsky130_fd_sc_hd__fill_8_1133 VSS VDD VDD sky130_fd_sc_hd__fill_8
* cell instance sky130_fd_sc_hd__fill_8_1134 r0 *1 0,0
Xsky130_fd_sc_hd__fill_8_1134 VSS VDD VDD sky130_fd_sc_hd__fill_8
* cell instance sky130_fd_sc_hd__fill_8_1135 r0 *1 0,0
Xsky130_fd_sc_hd__fill_8_1135 VSS VDD VDD sky130_fd_sc_hd__fill_8
* cell instance sky130_fd_sc_hd__fill_8_1136 r0 *1 0,0
Xsky130_fd_sc_hd__fill_8_1136 VSS VDD VDD sky130_fd_sc_hd__fill_8
* cell instance sky130_fd_sc_hd__fill_8_1137 r0 *1 0,0
Xsky130_fd_sc_hd__fill_8_1137 VSS VDD VDD sky130_fd_sc_hd__fill_8
* cell instance sky130_fd_sc_hd__fill_8_1138 r0 *1 0,0
Xsky130_fd_sc_hd__fill_8_1138 VSS VDD VDD sky130_fd_sc_hd__fill_8
* cell instance sky130_fd_sc_hd__fill_8_1139 r0 *1 0,0
Xsky130_fd_sc_hd__fill_8_1139 VSS VDD VDD sky130_fd_sc_hd__fill_8
* cell instance sky130_fd_sc_hd__fill_8_1140 r0 *1 0,0
Xsky130_fd_sc_hd__fill_8_1140 VSS VDD VDD sky130_fd_sc_hd__fill_8
* cell instance sky130_fd_sc_hd__fill_8_1141 r0 *1 0,0
Xsky130_fd_sc_hd__fill_8_1141 VSS VDD VDD sky130_fd_sc_hd__fill_8
* cell instance sky130_fd_sc_hd__fill_8_1142 r0 *1 0,0
Xsky130_fd_sc_hd__fill_8_1142 VSS VDD VDD sky130_fd_sc_hd__fill_8
* cell instance sky130_fd_sc_hd__fill_8_1143 r0 *1 0,0
Xsky130_fd_sc_hd__fill_8_1143 VSS VDD VDD sky130_fd_sc_hd__fill_8
* cell instance sky130_fd_sc_hd__fill_8_1144 r0 *1 0,0
Xsky130_fd_sc_hd__fill_8_1144 VSS VDD VDD sky130_fd_sc_hd__fill_8
* cell instance sky130_fd_sc_hd__fill_8_1145 r0 *1 0,0
Xsky130_fd_sc_hd__fill_8_1145 VSS VDD VDD sky130_fd_sc_hd__fill_8
* cell instance sky130_fd_sc_hd__fill_8_1146 r0 *1 0,0
Xsky130_fd_sc_hd__fill_8_1146 VSS VDD VDD sky130_fd_sc_hd__fill_8
* cell instance sky130_fd_sc_hd__fill_8_1147 r0 *1 0,0
Xsky130_fd_sc_hd__fill_8_1147 VSS VDD VDD sky130_fd_sc_hd__fill_8
* cell instance sky130_fd_sc_hd__fill_8_1148 r0 *1 0,0
Xsky130_fd_sc_hd__fill_8_1148 VSS VDD VDD sky130_fd_sc_hd__fill_8
* cell instance sky130_fd_sc_hd__fill_8_1149 r0 *1 0,0
Xsky130_fd_sc_hd__fill_8_1149 VSS VDD VDD sky130_fd_sc_hd__fill_8
* cell instance sky130_fd_sc_hd__fill_8_1150 r0 *1 0,0
Xsky130_fd_sc_hd__fill_8_1150 VSS VDD VDD sky130_fd_sc_hd__fill_8
* cell instance sky130_fd_sc_hd__fill_8_1151 r0 *1 0,0
Xsky130_fd_sc_hd__fill_8_1151 VSS VDD VDD sky130_fd_sc_hd__fill_8
* cell instance sky130_fd_sc_hd__fill_8_1152 r0 *1 0,0
Xsky130_fd_sc_hd__fill_8_1152 VSS VDD VDD sky130_fd_sc_hd__fill_8
* cell instance sky130_fd_sc_hd__fill_8_1153 r0 *1 0,0
Xsky130_fd_sc_hd__fill_8_1153 VSS VDD VDD sky130_fd_sc_hd__fill_8
* cell instance sky130_fd_sc_hd__fill_8_1154 r0 *1 0,0
Xsky130_fd_sc_hd__fill_8_1154 VSS VDD VDD sky130_fd_sc_hd__fill_8
* cell instance sky130_fd_sc_hd__fill_8_1155 r0 *1 0,0
Xsky130_fd_sc_hd__fill_8_1155 VSS VDD VDD sky130_fd_sc_hd__fill_8
* cell instance sky130_fd_sc_hd__fill_8_1156 r0 *1 0,0
Xsky130_fd_sc_hd__fill_8_1156 VSS VDD VDD sky130_fd_sc_hd__fill_8
* cell instance sky130_fd_sc_hd__fill_8_1157 r0 *1 0,0
Xsky130_fd_sc_hd__fill_8_1157 VSS VDD VDD sky130_fd_sc_hd__fill_8
* cell instance sky130_fd_sc_hd__fill_8_1158 r0 *1 0,0
Xsky130_fd_sc_hd__fill_8_1158 VSS VDD VDD sky130_fd_sc_hd__fill_8
* cell instance sky130_fd_sc_hd__fill_8_1159 r0 *1 0,0
Xsky130_fd_sc_hd__fill_8_1159 VSS VDD VDD sky130_fd_sc_hd__fill_8
* cell instance sky130_fd_sc_hd__fill_8_1160 r0 *1 0,0
Xsky130_fd_sc_hd__fill_8_1160 VSS VDD VDD sky130_fd_sc_hd__fill_8
* cell instance sky130_fd_sc_hd__fill_8_1161 r0 *1 0,0
Xsky130_fd_sc_hd__fill_8_1161 VSS VDD VDD sky130_fd_sc_hd__fill_8
* cell instance sky130_fd_sc_hd__fill_8_1162 r0 *1 0,0
Xsky130_fd_sc_hd__fill_8_1162 VSS VDD VDD sky130_fd_sc_hd__fill_8
* cell instance sky130_fd_sc_hd__fill_8_1163 r0 *1 0,0
Xsky130_fd_sc_hd__fill_8_1163 VSS VDD VDD sky130_fd_sc_hd__fill_8
* cell instance sky130_fd_sc_hd__fill_8_1164 r0 *1 0,0
Xsky130_fd_sc_hd__fill_8_1164 VSS VDD VDD sky130_fd_sc_hd__fill_8
* cell instance sky130_fd_sc_hd__fill_8_1165 r0 *1 0,0
Xsky130_fd_sc_hd__fill_8_1165 VSS VDD VDD sky130_fd_sc_hd__fill_8
* cell instance sky130_fd_sc_hd__fill_8_1166 r0 *1 0,0
Xsky130_fd_sc_hd__fill_8_1166 VSS VDD VDD sky130_fd_sc_hd__fill_8
* cell instance sky130_fd_sc_hd__fill_8_1167 r0 *1 0,0
Xsky130_fd_sc_hd__fill_8_1167 VSS VDD VDD sky130_fd_sc_hd__fill_8
* cell instance sky130_fd_sc_hd__fill_8_1168 r0 *1 0,0
Xsky130_fd_sc_hd__fill_8_1168 VSS VDD VDD sky130_fd_sc_hd__fill_8
* cell instance sky130_fd_sc_hd__fill_8_1169 r0 *1 0,0
Xsky130_fd_sc_hd__fill_8_1169 VSS VDD VDD sky130_fd_sc_hd__fill_8
* cell instance sky130_fd_sc_hd__fill_8_1170 r0 *1 0,0
Xsky130_fd_sc_hd__fill_8_1170 VSS VDD VDD sky130_fd_sc_hd__fill_8
* cell instance sky130_fd_sc_hd__fill_8_1171 r0 *1 0,0
Xsky130_fd_sc_hd__fill_8_1171 VSS VDD VDD sky130_fd_sc_hd__fill_8
* cell instance sky130_fd_sc_hd__fill_8_1172 r0 *1 0,0
Xsky130_fd_sc_hd__fill_8_1172 VSS VDD VDD sky130_fd_sc_hd__fill_8
* cell instance sky130_fd_sc_hd__fill_8_1173 r0 *1 0,0
Xsky130_fd_sc_hd__fill_8_1173 VSS VDD VDD sky130_fd_sc_hd__fill_8
* cell instance sky130_fd_sc_hd__fill_8_1174 r0 *1 0,0
Xsky130_fd_sc_hd__fill_8_1174 VSS VDD VDD sky130_fd_sc_hd__fill_8
* cell instance sky130_fd_sc_hd__fill_8_1175 r0 *1 0,0
Xsky130_fd_sc_hd__fill_8_1175 VSS VDD VDD sky130_fd_sc_hd__fill_8
* cell instance sky130_fd_sc_hd__fill_8_1176 r0 *1 0,0
Xsky130_fd_sc_hd__fill_8_1176 VSS VDD VDD sky130_fd_sc_hd__fill_8
* cell instance sky130_fd_sc_hd__fill_8_1177 r0 *1 0,0
Xsky130_fd_sc_hd__fill_8_1177 VSS VDD VDD sky130_fd_sc_hd__fill_8
* cell instance sky130_fd_sc_hd__fill_8_1178 r0 *1 0,0
Xsky130_fd_sc_hd__fill_8_1178 VSS VDD VDD sky130_fd_sc_hd__fill_8
* cell instance sky130_fd_sc_hd__fill_8_1179 r0 *1 0,0
Xsky130_fd_sc_hd__fill_8_1179 VSS VDD VDD sky130_fd_sc_hd__fill_8
* cell instance sky130_fd_sc_hd__fill_8_1180 r0 *1 0,0
Xsky130_fd_sc_hd__fill_8_1180 VSS VDD VDD sky130_fd_sc_hd__fill_8
* cell instance sky130_fd_sc_hd__fill_8_1181 r0 *1 0,0
Xsky130_fd_sc_hd__fill_8_1181 VSS VDD VDD sky130_fd_sc_hd__fill_8
* cell instance sky130_fd_sc_hd__fill_8_1182 r0 *1 0,0
Xsky130_fd_sc_hd__fill_8_1182 VSS VDD VDD sky130_fd_sc_hd__fill_8
* cell instance sky130_fd_sc_hd__fill_8_1183 r0 *1 0,0
Xsky130_fd_sc_hd__fill_8_1183 VSS VDD VDD sky130_fd_sc_hd__fill_8
* cell instance sky130_fd_sc_hd__fill_8_1184 r0 *1 0,0
Xsky130_fd_sc_hd__fill_8_1184 VSS VDD VDD sky130_fd_sc_hd__fill_8
* cell instance sky130_fd_sc_hd__fill_8_1185 r0 *1 0,0
Xsky130_fd_sc_hd__fill_8_1185 VSS VDD VDD sky130_fd_sc_hd__fill_8
* cell instance sky130_fd_sc_hd__fill_8_1186 r0 *1 0,0
Xsky130_fd_sc_hd__fill_8_1186 VSS VDD VDD sky130_fd_sc_hd__fill_8
* cell instance sky130_fd_sc_hd__fill_8_1187 r0 *1 0,0
Xsky130_fd_sc_hd__fill_8_1187 VSS VDD VDD sky130_fd_sc_hd__fill_8
* cell instance sky130_fd_sc_hd__fill_8_1188 r0 *1 0,0
Xsky130_fd_sc_hd__fill_8_1188 VSS VDD VDD sky130_fd_sc_hd__fill_8
* cell instance sky130_fd_sc_hd__fill_8_1189 r0 *1 0,0
Xsky130_fd_sc_hd__fill_8_1189 VSS VDD VDD sky130_fd_sc_hd__fill_8
* cell instance sky130_fd_sc_hd__fill_8_1190 r0 *1 0,0
Xsky130_fd_sc_hd__fill_8_1190 VSS VDD VDD sky130_fd_sc_hd__fill_8
* cell instance sky130_fd_sc_hd__fill_8_1191 r0 *1 0,0
Xsky130_fd_sc_hd__fill_8_1191 VSS VDD VDD sky130_fd_sc_hd__fill_8
* cell instance sky130_fd_sc_hd__fill_8_1192 r0 *1 0,0
Xsky130_fd_sc_hd__fill_8_1192 VSS VDD VDD sky130_fd_sc_hd__fill_8
* cell instance sky130_fd_sc_hd__fill_8_1193 r0 *1 0,0
Xsky130_fd_sc_hd__fill_8_1193 VSS VDD VDD sky130_fd_sc_hd__fill_8
* cell instance sky130_fd_sc_hd__fill_8_1194 r0 *1 0,0
Xsky130_fd_sc_hd__fill_8_1194 VSS VDD VDD sky130_fd_sc_hd__fill_8
* cell instance sky130_fd_sc_hd__fill_8_1195 r0 *1 0,0
Xsky130_fd_sc_hd__fill_8_1195 VSS VDD VDD sky130_fd_sc_hd__fill_8
* cell instance sky130_fd_sc_hd__fill_8_1196 r0 *1 0,0
Xsky130_fd_sc_hd__fill_8_1196 VSS VDD VDD sky130_fd_sc_hd__fill_8
* cell instance sky130_fd_sc_hd__fill_8_1197 r0 *1 0,0
Xsky130_fd_sc_hd__fill_8_1197 VSS VDD VDD sky130_fd_sc_hd__fill_8
* cell instance sky130_fd_sc_hd__fill_8_1198 r0 *1 0,0
Xsky130_fd_sc_hd__fill_8_1198 VSS VDD VDD sky130_fd_sc_hd__fill_8
* cell instance sky130_fd_sc_hd__fill_8_1199 r0 *1 0,0
Xsky130_fd_sc_hd__fill_8_1199 VSS VDD VDD sky130_fd_sc_hd__fill_8
* cell instance sky130_fd_sc_hd__fill_8_1200 r0 *1 0,0
Xsky130_fd_sc_hd__fill_8_1200 VSS VDD VDD sky130_fd_sc_hd__fill_8
* cell instance sky130_fd_sc_hd__fill_8_1201 r0 *1 0,0
Xsky130_fd_sc_hd__fill_8_1201 VSS VDD VDD sky130_fd_sc_hd__fill_8
* cell instance sky130_fd_sc_hd__fill_8_1202 r0 *1 0,0
Xsky130_fd_sc_hd__fill_8_1202 VSS VDD VDD sky130_fd_sc_hd__fill_8
* cell instance sky130_fd_sc_hd__fill_8_1203 r0 *1 0,0
Xsky130_fd_sc_hd__fill_8_1203 VSS VDD VDD sky130_fd_sc_hd__fill_8
* cell instance sky130_fd_sc_hd__fill_8_1204 r0 *1 0,0
Xsky130_fd_sc_hd__fill_8_1204 VSS VDD VDD sky130_fd_sc_hd__fill_8
* cell instance sky130_fd_sc_hd__fill_8_1205 r0 *1 0,0
Xsky130_fd_sc_hd__fill_8_1205 VSS VDD VDD sky130_fd_sc_hd__fill_8
* cell instance sky130_fd_sc_hd__fill_8_1206 r0 *1 0,0
Xsky130_fd_sc_hd__fill_8_1206 VSS VDD VDD sky130_fd_sc_hd__fill_8
* cell instance sky130_fd_sc_hd__fill_8_1207 r0 *1 0,0
Xsky130_fd_sc_hd__fill_8_1207 VSS VDD VDD sky130_fd_sc_hd__fill_8
* cell instance sky130_fd_sc_hd__fill_8_1208 r0 *1 0,0
Xsky130_fd_sc_hd__fill_8_1208 VSS VDD VDD sky130_fd_sc_hd__fill_8
* cell instance sky130_fd_sc_hd__fill_8_1209 r0 *1 0,0
Xsky130_fd_sc_hd__fill_8_1209 VSS VDD VDD sky130_fd_sc_hd__fill_8
* cell instance sky130_fd_sc_hd__fill_8_1210 r0 *1 0,0
Xsky130_fd_sc_hd__fill_8_1210 VSS VDD VDD sky130_fd_sc_hd__fill_8
* cell instance sky130_fd_sc_hd__fill_8_1211 r0 *1 0,0
Xsky130_fd_sc_hd__fill_8_1211 VSS VDD VDD sky130_fd_sc_hd__fill_8
* cell instance sky130_fd_sc_hd__fill_8_1212 r0 *1 0,0
Xsky130_fd_sc_hd__fill_8_1212 VSS VDD VDD sky130_fd_sc_hd__fill_8
* cell instance sky130_fd_sc_hd__fill_8_1213 r0 *1 0,0
Xsky130_fd_sc_hd__fill_8_1213 VSS VDD VDD sky130_fd_sc_hd__fill_8
* cell instance sky130_fd_sc_hd__fill_8_1214 r0 *1 0,0
Xsky130_fd_sc_hd__fill_8_1214 VSS VDD VDD sky130_fd_sc_hd__fill_8
* cell instance sky130_fd_sc_hd__fill_8_1215 r0 *1 0,0
Xsky130_fd_sc_hd__fill_8_1215 VSS VDD VDD sky130_fd_sc_hd__fill_8
* cell instance sky130_fd_sc_hd__fill_8_1216 r0 *1 0,0
Xsky130_fd_sc_hd__fill_8_1216 VSS VDD VDD sky130_fd_sc_hd__fill_8
* cell instance sky130_fd_sc_hd__fill_8_1217 r0 *1 0,0
Xsky130_fd_sc_hd__fill_8_1217 VSS VDD VDD sky130_fd_sc_hd__fill_8
* cell instance sky130_fd_sc_hd__fill_8_1218 r0 *1 0,0
Xsky130_fd_sc_hd__fill_8_1218 VSS VDD VDD sky130_fd_sc_hd__fill_8
* cell instance sky130_fd_sc_hd__fill_8_1219 r0 *1 0,0
Xsky130_fd_sc_hd__fill_8_1219 VSS VDD VDD sky130_fd_sc_hd__fill_8
* cell instance sky130_fd_sc_hd__fill_8_1220 r0 *1 0,0
Xsky130_fd_sc_hd__fill_8_1220 VSS VDD VDD sky130_fd_sc_hd__fill_8
* cell instance sky130_fd_sc_hd__fill_8_1221 r0 *1 0,0
Xsky130_fd_sc_hd__fill_8_1221 VSS VDD VDD sky130_fd_sc_hd__fill_8
* cell instance sky130_fd_sc_hd__fill_8_1222 r0 *1 0,0
Xsky130_fd_sc_hd__fill_8_1222 VSS VDD VDD sky130_fd_sc_hd__fill_8
* cell instance sky130_fd_sc_hd__fill_8_1223 r0 *1 0,0
Xsky130_fd_sc_hd__fill_8_1223 VSS VDD VDD sky130_fd_sc_hd__fill_8
* cell instance sky130_fd_sc_hd__fill_8_1224 r0 *1 0,0
Xsky130_fd_sc_hd__fill_8_1224 VSS VDD VDD sky130_fd_sc_hd__fill_8
* cell instance sky130_fd_sc_hd__fill_8_1225 r0 *1 0,0
Xsky130_fd_sc_hd__fill_8_1225 VSS VDD VDD sky130_fd_sc_hd__fill_8
* cell instance sky130_fd_sc_hd__fill_8_1226 r0 *1 0,0
Xsky130_fd_sc_hd__fill_8_1226 VSS VDD VDD sky130_fd_sc_hd__fill_8
* cell instance sky130_fd_sc_hd__fill_8_1227 r0 *1 0,0
Xsky130_fd_sc_hd__fill_8_1227 VSS VDD VDD sky130_fd_sc_hd__fill_8
* cell instance sky130_fd_sc_hd__fill_8_1228 r0 *1 0,0
Xsky130_fd_sc_hd__fill_8_1228 VSS VDD VDD sky130_fd_sc_hd__fill_8
* cell instance sky130_fd_sc_hd__fill_8_1229 r0 *1 0,0
Xsky130_fd_sc_hd__fill_8_1229 VSS VDD VDD sky130_fd_sc_hd__fill_8
* cell instance sky130_fd_sc_hd__fill_8_1230 r0 *1 0,0
Xsky130_fd_sc_hd__fill_8_1230 VSS VDD VDD sky130_fd_sc_hd__fill_8
* cell instance sky130_fd_sc_hd__fill_8_1231 r0 *1 0,0
Xsky130_fd_sc_hd__fill_8_1231 VSS VDD VDD sky130_fd_sc_hd__fill_8
* cell instance sky130_fd_sc_hd__fill_8_1232 r0 *1 0,0
Xsky130_fd_sc_hd__fill_8_1232 VSS VDD VDD sky130_fd_sc_hd__fill_8
* cell instance sky130_fd_sc_hd__fill_8_1233 r0 *1 0,0
Xsky130_fd_sc_hd__fill_8_1233 VSS VDD VDD sky130_fd_sc_hd__fill_8
* cell instance sky130_fd_sc_hd__fill_8_1234 r0 *1 0,0
Xsky130_fd_sc_hd__fill_8_1234 VSS VDD VDD sky130_fd_sc_hd__fill_8
* cell instance sky130_fd_sc_hd__fill_8_1235 r0 *1 0,0
Xsky130_fd_sc_hd__fill_8_1235 VSS VDD VDD sky130_fd_sc_hd__fill_8
* cell instance sky130_fd_sc_hd__fill_8_1236 r0 *1 0,0
Xsky130_fd_sc_hd__fill_8_1236 VSS VDD VDD sky130_fd_sc_hd__fill_8
* cell instance sky130_fd_sc_hd__fill_8_1237 r0 *1 0,0
Xsky130_fd_sc_hd__fill_8_1237 VSS VDD VDD sky130_fd_sc_hd__fill_8
* cell instance sky130_fd_sc_hd__fill_8_1238 r0 *1 0,0
Xsky130_fd_sc_hd__fill_8_1238 VSS VDD VDD sky130_fd_sc_hd__fill_8
* cell instance sky130_fd_sc_hd__fill_8_1239 r0 *1 0,0
Xsky130_fd_sc_hd__fill_8_1239 VSS VDD VDD sky130_fd_sc_hd__fill_8
* cell instance sky130_fd_sc_hd__fill_8_1240 r0 *1 0,0
Xsky130_fd_sc_hd__fill_8_1240 VSS VDD VDD sky130_fd_sc_hd__fill_8
* cell instance sky130_fd_sc_hd__fill_8_1241 r0 *1 0,0
Xsky130_fd_sc_hd__fill_8_1241 VSS VDD VDD sky130_fd_sc_hd__fill_8
* cell instance sky130_fd_sc_hd__fill_8_1242 r0 *1 0,0
Xsky130_fd_sc_hd__fill_8_1242 VSS VDD VDD sky130_fd_sc_hd__fill_8
* cell instance sky130_fd_sc_hd__fill_8_1243 r0 *1 0,0
Xsky130_fd_sc_hd__fill_8_1243 VSS VDD VDD sky130_fd_sc_hd__fill_8
* cell instance sky130_fd_sc_hd__fill_8_1244 r0 *1 0,0
Xsky130_fd_sc_hd__fill_8_1244 VSS VDD VDD sky130_fd_sc_hd__fill_8
* cell instance sky130_fd_sc_hd__fill_8_1245 r0 *1 0,0
Xsky130_fd_sc_hd__fill_8_1245 VSS VDD VDD sky130_fd_sc_hd__fill_8
* cell instance sky130_fd_sc_hd__fill_8_1246 r0 *1 0,0
Xsky130_fd_sc_hd__fill_8_1246 VSS VDD VDD sky130_fd_sc_hd__fill_8
* cell instance sky130_fd_sc_hd__fill_8_1247 r0 *1 0,0
Xsky130_fd_sc_hd__fill_8_1247 VSS VDD VDD sky130_fd_sc_hd__fill_8
* cell instance sky130_fd_sc_hd__fill_8_1248 r0 *1 0,0
Xsky130_fd_sc_hd__fill_8_1248 VSS VDD VDD sky130_fd_sc_hd__fill_8
* cell instance sky130_fd_sc_hd__fill_8_1249 r0 *1 0,0
Xsky130_fd_sc_hd__fill_8_1249 VSS VDD VDD sky130_fd_sc_hd__fill_8
* cell instance sky130_fd_sc_hd__fill_8_1250 r0 *1 0,0
Xsky130_fd_sc_hd__fill_8_1250 VSS VDD VDD sky130_fd_sc_hd__fill_8
* cell instance sky130_fd_sc_hd__fill_8_1251 r0 *1 0,0
Xsky130_fd_sc_hd__fill_8_1251 VSS VDD VDD sky130_fd_sc_hd__fill_8
* cell instance sky130_fd_sc_hd__fill_8_1252 r0 *1 0,0
Xsky130_fd_sc_hd__fill_8_1252 VSS VDD VDD sky130_fd_sc_hd__fill_8
* cell instance sky130_fd_sc_hd__fill_8_1253 r0 *1 0,0
Xsky130_fd_sc_hd__fill_8_1253 VSS VDD VDD sky130_fd_sc_hd__fill_8
* cell instance sky130_fd_sc_hd__fill_8_1254 r0 *1 0,0
Xsky130_fd_sc_hd__fill_8_1254 VSS VDD VDD sky130_fd_sc_hd__fill_8
* cell instance sky130_fd_sc_hd__fill_8_1255 r0 *1 0,0
Xsky130_fd_sc_hd__fill_8_1255 VSS VDD VDD sky130_fd_sc_hd__fill_8
* cell instance sky130_fd_sc_hd__fill_8_1256 r0 *1 0,0
Xsky130_fd_sc_hd__fill_8_1256 VSS VDD VDD sky130_fd_sc_hd__fill_8
* cell instance sky130_fd_sc_hd__fill_8_1257 r0 *1 0,0
Xsky130_fd_sc_hd__fill_8_1257 VSS VDD VDD sky130_fd_sc_hd__fill_8
* cell instance sky130_fd_sc_hd__fill_8_1258 r0 *1 0,0
Xsky130_fd_sc_hd__fill_8_1258 VSS VDD VDD sky130_fd_sc_hd__fill_8
* cell instance sky130_fd_sc_hd__fill_8_1259 r0 *1 0,0
Xsky130_fd_sc_hd__fill_8_1259 VSS VDD VDD sky130_fd_sc_hd__fill_8
* cell instance sky130_fd_sc_hd__fill_8_1260 r0 *1 0,0
Xsky130_fd_sc_hd__fill_8_1260 VSS VDD VDD sky130_fd_sc_hd__fill_8
* cell instance sky130_fd_sc_hd__fill_8_1261 r0 *1 0,0
Xsky130_fd_sc_hd__fill_8_1261 VSS VDD VDD sky130_fd_sc_hd__fill_8
* cell instance sky130_fd_sc_hd__fill_8_1262 r0 *1 0,0
Xsky130_fd_sc_hd__fill_8_1262 VSS VDD VDD sky130_fd_sc_hd__fill_8
* cell instance sky130_fd_sc_hd__fill_8_1263 r0 *1 0,0
Xsky130_fd_sc_hd__fill_8_1263 VSS VDD VDD sky130_fd_sc_hd__fill_8
* cell instance sky130_fd_sc_hd__fill_8_1264 r0 *1 0,0
Xsky130_fd_sc_hd__fill_8_1264 VSS VDD VDD sky130_fd_sc_hd__fill_8
* cell instance sky130_fd_sc_hd__fill_8_1265 r0 *1 0,0
Xsky130_fd_sc_hd__fill_8_1265 VSS VDD VDD sky130_fd_sc_hd__fill_8
* cell instance sky130_fd_sc_hd__fill_8_1266 r0 *1 0,0
Xsky130_fd_sc_hd__fill_8_1266 VSS VDD VDD sky130_fd_sc_hd__fill_8
* cell instance sky130_fd_sc_hd__fill_8_1267 r0 *1 0,0
Xsky130_fd_sc_hd__fill_8_1267 VSS VDD VDD sky130_fd_sc_hd__fill_8
* cell instance sky130_fd_sc_hd__fill_8_1268 r0 *1 0,0
Xsky130_fd_sc_hd__fill_8_1268 VSS VDD VDD sky130_fd_sc_hd__fill_8
* cell instance sky130_fd_sc_hd__fill_8_1269 r0 *1 0,0
Xsky130_fd_sc_hd__fill_8_1269 VSS VDD VDD sky130_fd_sc_hd__fill_8
* cell instance sky130_fd_sc_hd__fill_8_1270 r0 *1 0,0
Xsky130_fd_sc_hd__fill_8_1270 VSS VDD VDD sky130_fd_sc_hd__fill_8
* cell instance sky130_fd_sc_hd__fill_8_1271 r0 *1 0,0
Xsky130_fd_sc_hd__fill_8_1271 VSS VDD VDD sky130_fd_sc_hd__fill_8
* cell instance sky130_fd_sc_hd__fill_8_1272 r0 *1 0,0
Xsky130_fd_sc_hd__fill_8_1272 VSS VDD VDD sky130_fd_sc_hd__fill_8
* cell instance sky130_fd_sc_hd__fill_8_1273 r0 *1 0,0
Xsky130_fd_sc_hd__fill_8_1273 VSS VDD VDD sky130_fd_sc_hd__fill_8
* cell instance sky130_fd_sc_hd__fill_8_1274 r0 *1 0,0
Xsky130_fd_sc_hd__fill_8_1274 VSS VDD VDD sky130_fd_sc_hd__fill_8
* cell instance sky130_fd_sc_hd__fill_8_1275 r0 *1 0,0
Xsky130_fd_sc_hd__fill_8_1275 VSS VDD VDD sky130_fd_sc_hd__fill_8
* cell instance sky130_fd_sc_hd__fill_8_1276 r0 *1 0,0
Xsky130_fd_sc_hd__fill_8_1276 VSS VDD VDD sky130_fd_sc_hd__fill_8
* cell instance sky130_fd_sc_hd__fill_8_1277 r0 *1 0,0
Xsky130_fd_sc_hd__fill_8_1277 VSS VDD VDD sky130_fd_sc_hd__fill_8
* cell instance sky130_fd_sc_hd__fill_8_1278 r0 *1 0,0
Xsky130_fd_sc_hd__fill_8_1278 VSS VDD VDD sky130_fd_sc_hd__fill_8
* cell instance sky130_fd_sc_hd__fill_8_1279 r0 *1 0,0
Xsky130_fd_sc_hd__fill_8_1279 VSS VDD VDD sky130_fd_sc_hd__fill_8
* cell instance sky130_fd_sc_hd__fill_8_1280 r0 *1 0,0
Xsky130_fd_sc_hd__fill_8_1280 VSS VDD VDD sky130_fd_sc_hd__fill_8
* cell instance sky130_fd_sc_hd__fill_8_1281 r0 *1 0,0
Xsky130_fd_sc_hd__fill_8_1281 VSS VDD VDD sky130_fd_sc_hd__fill_8
* cell instance sky130_fd_sc_hd__fill_8_1282 r0 *1 0,0
Xsky130_fd_sc_hd__fill_8_1282 VSS VDD VDD sky130_fd_sc_hd__fill_8
* cell instance sky130_fd_sc_hd__fill_8_1283 r0 *1 0,0
Xsky130_fd_sc_hd__fill_8_1283 VSS VDD VDD sky130_fd_sc_hd__fill_8
* cell instance sky130_fd_sc_hd__fill_8_1284 r0 *1 0,0
Xsky130_fd_sc_hd__fill_8_1284 VSS VDD VDD sky130_fd_sc_hd__fill_8
* cell instance sky130_fd_sc_hd__fill_8_1285 r0 *1 0,0
Xsky130_fd_sc_hd__fill_8_1285 VSS VDD VDD sky130_fd_sc_hd__fill_8
* cell instance sky130_fd_sc_hd__fill_8_1286 r0 *1 0,0
Xsky130_fd_sc_hd__fill_8_1286 VSS VDD VDD sky130_fd_sc_hd__fill_8
* cell instance sky130_fd_sc_hd__fill_8_1287 r0 *1 0,0
Xsky130_fd_sc_hd__fill_8_1287 VSS VDD VDD sky130_fd_sc_hd__fill_8
* cell instance sky130_fd_sc_hd__fill_8_1288 r0 *1 0,0
Xsky130_fd_sc_hd__fill_8_1288 VSS VDD VDD sky130_fd_sc_hd__fill_8
* cell instance sky130_fd_sc_hd__fill_8_1289 r0 *1 0,0
Xsky130_fd_sc_hd__fill_8_1289 VSS VDD VDD sky130_fd_sc_hd__fill_8
* cell instance sky130_fd_sc_hd__fill_8_1290 r0 *1 0,0
Xsky130_fd_sc_hd__fill_8_1290 VSS VDD VDD sky130_fd_sc_hd__fill_8
* cell instance sky130_fd_sc_hd__fill_8_1291 r0 *1 0,0
Xsky130_fd_sc_hd__fill_8_1291 VSS VDD VDD sky130_fd_sc_hd__fill_8
* cell instance sky130_fd_sc_hd__fill_8_1292 r0 *1 0,0
Xsky130_fd_sc_hd__fill_8_1292 VSS VDD VDD sky130_fd_sc_hd__fill_8
* cell instance sky130_fd_sc_hd__fill_8_1293 r0 *1 0,0
Xsky130_fd_sc_hd__fill_8_1293 VSS VDD VDD sky130_fd_sc_hd__fill_8
* cell instance sky130_fd_sc_hd__fill_8_1294 r0 *1 0,0
Xsky130_fd_sc_hd__fill_8_1294 VSS VDD VDD sky130_fd_sc_hd__fill_8
* cell instance sky130_fd_sc_hd__fill_8_1295 r0 *1 0,0
Xsky130_fd_sc_hd__fill_8_1295 VSS VDD VDD sky130_fd_sc_hd__fill_8
* cell instance sky130_fd_sc_hd__fill_8_1296 r0 *1 0,0
Xsky130_fd_sc_hd__fill_8_1296 VSS VDD VDD sky130_fd_sc_hd__fill_8
* cell instance sky130_fd_sc_hd__fill_8_1297 r0 *1 0,0
Xsky130_fd_sc_hd__fill_8_1297 VSS VDD VDD sky130_fd_sc_hd__fill_8
* cell instance sky130_fd_sc_hd__fill_8_1298 r0 *1 0,0
Xsky130_fd_sc_hd__fill_8_1298 VSS VDD VDD sky130_fd_sc_hd__fill_8
* cell instance sky130_fd_sc_hd__fill_8_1299 r0 *1 0,0
Xsky130_fd_sc_hd__fill_8_1299 VSS VDD VDD sky130_fd_sc_hd__fill_8
* cell instance sky130_fd_sc_hd__fill_8_1300 r0 *1 0,0
Xsky130_fd_sc_hd__fill_8_1300 VSS VDD VDD sky130_fd_sc_hd__fill_8
* cell instance sky130_fd_sc_hd__fill_8_1301 r0 *1 0,0
Xsky130_fd_sc_hd__fill_8_1301 VSS VDD VDD sky130_fd_sc_hd__fill_8
* cell instance sky130_fd_sc_hd__fill_8_1302 r0 *1 0,0
Xsky130_fd_sc_hd__fill_8_1302 VSS VDD VDD sky130_fd_sc_hd__fill_8
* cell instance sky130_fd_sc_hd__fill_8_1303 r0 *1 0,0
Xsky130_fd_sc_hd__fill_8_1303 VSS VDD VDD sky130_fd_sc_hd__fill_8
* cell instance sky130_fd_sc_hd__fill_8_1304 r0 *1 0,0
Xsky130_fd_sc_hd__fill_8_1304 VSS VDD VDD sky130_fd_sc_hd__fill_8
* cell instance sky130_fd_sc_hd__fill_8_1305 r0 *1 0,0
Xsky130_fd_sc_hd__fill_8_1305 VSS VDD VDD sky130_fd_sc_hd__fill_8
* cell instance sky130_fd_sc_hd__fill_8_1306 r0 *1 0,0
Xsky130_fd_sc_hd__fill_8_1306 VSS VDD VDD sky130_fd_sc_hd__fill_8
* cell instance sky130_fd_sc_hd__fill_8_1307 r0 *1 0,0
Xsky130_fd_sc_hd__fill_8_1307 VSS VDD VDD sky130_fd_sc_hd__fill_8
* cell instance sky130_fd_sc_hd__fill_8_1308 r0 *1 0,0
Xsky130_fd_sc_hd__fill_8_1308 VSS VDD VDD sky130_fd_sc_hd__fill_8
* cell instance sky130_fd_sc_hd__fill_8_1309 r0 *1 0,0
Xsky130_fd_sc_hd__fill_8_1309 VSS VDD VDD sky130_fd_sc_hd__fill_8
* cell instance sky130_fd_sc_hd__fill_8_1310 r0 *1 0,0
Xsky130_fd_sc_hd__fill_8_1310 VSS VDD VDD sky130_fd_sc_hd__fill_8
* cell instance sky130_fd_sc_hd__fill_8_1311 r0 *1 0,0
Xsky130_fd_sc_hd__fill_8_1311 VSS VDD VDD sky130_fd_sc_hd__fill_8
* cell instance sky130_fd_sc_hd__fill_8_1312 r0 *1 0,0
Xsky130_fd_sc_hd__fill_8_1312 VSS VDD VDD sky130_fd_sc_hd__fill_8
* cell instance sky130_fd_sc_hd__fill_8_1313 r0 *1 0,0
Xsky130_fd_sc_hd__fill_8_1313 VSS VDD VDD sky130_fd_sc_hd__fill_8
* cell instance sky130_fd_sc_hd__fill_8_1314 r0 *1 0,0
Xsky130_fd_sc_hd__fill_8_1314 VSS VDD VDD sky130_fd_sc_hd__fill_8
* cell instance sky130_fd_sc_hd__fill_8_1315 r0 *1 0,0
Xsky130_fd_sc_hd__fill_8_1315 VSS VDD VDD sky130_fd_sc_hd__fill_8
* cell instance sky130_fd_sc_hd__fill_8_1316 r0 *1 0,0
Xsky130_fd_sc_hd__fill_8_1316 VSS VDD VDD sky130_fd_sc_hd__fill_8
* cell instance sky130_fd_sc_hd__fill_8_1317 r0 *1 0,0
Xsky130_fd_sc_hd__fill_8_1317 VSS VDD VDD sky130_fd_sc_hd__fill_8
* cell instance sky130_fd_sc_hd__fill_8_1318 r0 *1 0,0
Xsky130_fd_sc_hd__fill_8_1318 VSS VDD VDD sky130_fd_sc_hd__fill_8
* cell instance sky130_fd_sc_hd__fill_8_1319 r0 *1 0,0
Xsky130_fd_sc_hd__fill_8_1319 VSS VDD VDD sky130_fd_sc_hd__fill_8
* cell instance sky130_fd_sc_hd__fill_8_1320 r0 *1 0,0
Xsky130_fd_sc_hd__fill_8_1320 VSS VDD VDD sky130_fd_sc_hd__fill_8
* cell instance sky130_fd_sc_hd__fill_8_1321 r0 *1 0,0
Xsky130_fd_sc_hd__fill_8_1321 VSS VDD VDD sky130_fd_sc_hd__fill_8
* cell instance sky130_fd_sc_hd__fill_8_1322 r0 *1 0,0
Xsky130_fd_sc_hd__fill_8_1322 VSS VDD VDD sky130_fd_sc_hd__fill_8
* cell instance sky130_fd_sc_hd__fill_8_1323 r0 *1 0,0
Xsky130_fd_sc_hd__fill_8_1323 VSS VDD VDD sky130_fd_sc_hd__fill_8
* cell instance sky130_fd_sc_hd__fill_8_1324 r0 *1 0,0
Xsky130_fd_sc_hd__fill_8_1324 VSS VDD VDD sky130_fd_sc_hd__fill_8
* cell instance sky130_fd_sc_hd__fill_8_1325 r0 *1 0,0
Xsky130_fd_sc_hd__fill_8_1325 VSS VDD VDD sky130_fd_sc_hd__fill_8
* cell instance sky130_fd_sc_hd__fill_8_1326 r0 *1 0,0
Xsky130_fd_sc_hd__fill_8_1326 VSS VDD VDD sky130_fd_sc_hd__fill_8
* cell instance sky130_fd_sc_hd__fill_8_1327 r0 *1 0,0
Xsky130_fd_sc_hd__fill_8_1327 VSS VDD VDD sky130_fd_sc_hd__fill_8
* cell instance sky130_fd_sc_hd__fill_8_1328 r0 *1 0,0
Xsky130_fd_sc_hd__fill_8_1328 VSS VDD VDD sky130_fd_sc_hd__fill_8
* cell instance sky130_fd_sc_hd__fill_8_1329 r0 *1 0,0
Xsky130_fd_sc_hd__fill_8_1329 VSS VDD VDD sky130_fd_sc_hd__fill_8
* cell instance sky130_fd_sc_hd__fill_8_1330 r0 *1 0,0
Xsky130_fd_sc_hd__fill_8_1330 VSS VDD VDD sky130_fd_sc_hd__fill_8
* cell instance sky130_fd_sc_hd__fill_8_1331 r0 *1 0,0
Xsky130_fd_sc_hd__fill_8_1331 VSS VDD VDD sky130_fd_sc_hd__fill_8
* cell instance sky130_fd_sc_hd__fill_8_1332 r0 *1 0,0
Xsky130_fd_sc_hd__fill_8_1332 VSS VDD VDD sky130_fd_sc_hd__fill_8
* cell instance sky130_fd_sc_hd__fill_8_1333 r0 *1 0,0
Xsky130_fd_sc_hd__fill_8_1333 VSS VDD VDD sky130_fd_sc_hd__fill_8
* cell instance sky130_fd_sc_hd__fill_8_1334 r0 *1 0,0
Xsky130_fd_sc_hd__fill_8_1334 VSS VDD VDD sky130_fd_sc_hd__fill_8
* cell instance sky130_fd_sc_hd__fill_8_1335 r0 *1 0,0
Xsky130_fd_sc_hd__fill_8_1335 VSS VDD VDD sky130_fd_sc_hd__fill_8
* cell instance sky130_fd_sc_hd__fill_8_1336 r0 *1 0,0
Xsky130_fd_sc_hd__fill_8_1336 VSS VDD VDD sky130_fd_sc_hd__fill_8
* cell instance sky130_fd_sc_hd__fill_8_1337 r0 *1 0,0
Xsky130_fd_sc_hd__fill_8_1337 VSS VDD VDD sky130_fd_sc_hd__fill_8
* cell instance sky130_fd_sc_hd__fill_8_1338 r0 *1 0,0
Xsky130_fd_sc_hd__fill_8_1338 VSS VDD VDD sky130_fd_sc_hd__fill_8
* cell instance sky130_fd_sc_hd__fill_8_1339 r0 *1 0,0
Xsky130_fd_sc_hd__fill_8_1339 VSS VDD VDD sky130_fd_sc_hd__fill_8
* cell instance sky130_fd_sc_hd__fill_8_1340 r0 *1 0,0
Xsky130_fd_sc_hd__fill_8_1340 VSS VDD VDD sky130_fd_sc_hd__fill_8
* cell instance sky130_fd_sc_hd__fill_8_1341 r0 *1 0,0
Xsky130_fd_sc_hd__fill_8_1341 VSS VDD VDD sky130_fd_sc_hd__fill_8
* cell instance sky130_fd_sc_hd__fill_8_1342 r0 *1 0,0
Xsky130_fd_sc_hd__fill_8_1342 VSS VDD VDD sky130_fd_sc_hd__fill_8
* cell instance sky130_fd_sc_hd__fill_8_1343 r0 *1 0,0
Xsky130_fd_sc_hd__fill_8_1343 VSS VDD VDD sky130_fd_sc_hd__fill_8
* cell instance sky130_fd_sc_hd__fill_8_1344 r0 *1 0,0
Xsky130_fd_sc_hd__fill_8_1344 VSS VDD VDD sky130_fd_sc_hd__fill_8
* cell instance sky130_fd_sc_hd__fill_8_1345 r0 *1 0,0
Xsky130_fd_sc_hd__fill_8_1345 VSS VDD VDD sky130_fd_sc_hd__fill_8
* cell instance sky130_fd_sc_hd__fill_8_1346 r0 *1 0,0
Xsky130_fd_sc_hd__fill_8_1346 VSS VDD VDD sky130_fd_sc_hd__fill_8
* cell instance sky130_fd_sc_hd__fill_8_1347 r0 *1 0,0
Xsky130_fd_sc_hd__fill_8_1347 VSS VDD VDD sky130_fd_sc_hd__fill_8
* cell instance sky130_fd_sc_hd__fill_8_1348 r0 *1 0,0
Xsky130_fd_sc_hd__fill_8_1348 VSS VDD VDD sky130_fd_sc_hd__fill_8
* cell instance sky130_fd_sc_hd__fill_8_1349 r0 *1 0,0
Xsky130_fd_sc_hd__fill_8_1349 VSS VDD VDD sky130_fd_sc_hd__fill_8
* cell instance sky130_fd_sc_hd__fill_8_1350 r0 *1 0,0
Xsky130_fd_sc_hd__fill_8_1350 VSS VDD VDD sky130_fd_sc_hd__fill_8
* cell instance sky130_fd_sc_hd__fill_8_1351 r0 *1 0,0
Xsky130_fd_sc_hd__fill_8_1351 VSS VDD VDD sky130_fd_sc_hd__fill_8
* cell instance sky130_fd_sc_hd__fill_8_1352 r0 *1 0,0
Xsky130_fd_sc_hd__fill_8_1352 VSS VDD VDD sky130_fd_sc_hd__fill_8
* cell instance sky130_fd_sc_hd__fill_8_1353 r0 *1 0,0
Xsky130_fd_sc_hd__fill_8_1353 VSS VDD VDD sky130_fd_sc_hd__fill_8
* cell instance sky130_fd_sc_hd__fill_8_1354 r0 *1 0,0
Xsky130_fd_sc_hd__fill_8_1354 VSS VDD VDD sky130_fd_sc_hd__fill_8
* cell instance sky130_fd_sc_hd__fill_8_1355 r0 *1 0,0
Xsky130_fd_sc_hd__fill_8_1355 VSS VDD VDD sky130_fd_sc_hd__fill_8
* cell instance sky130_fd_sc_hd__fill_8_1356 r0 *1 0,0
Xsky130_fd_sc_hd__fill_8_1356 VSS VDD VDD sky130_fd_sc_hd__fill_8
* cell instance sky130_fd_sc_hd__fill_8_1357 r0 *1 0,0
Xsky130_fd_sc_hd__fill_8_1357 VSS VDD VDD sky130_fd_sc_hd__fill_8
* cell instance sky130_fd_sc_hd__fill_8_1358 r0 *1 0,0
Xsky130_fd_sc_hd__fill_8_1358 VSS VDD VDD sky130_fd_sc_hd__fill_8
* cell instance sky130_fd_sc_hd__fill_8_1359 r0 *1 0,0
Xsky130_fd_sc_hd__fill_8_1359 VSS VDD VDD sky130_fd_sc_hd__fill_8
* cell instance sky130_fd_sc_hd__fill_8_1360 r0 *1 0,0
Xsky130_fd_sc_hd__fill_8_1360 VSS VDD VDD sky130_fd_sc_hd__fill_8
* cell instance sky130_fd_sc_hd__fill_8_1361 r0 *1 0,0
Xsky130_fd_sc_hd__fill_8_1361 VSS VDD VDD sky130_fd_sc_hd__fill_8
* cell instance sky130_fd_sc_hd__fill_8_1362 r0 *1 0,0
Xsky130_fd_sc_hd__fill_8_1362 VSS VDD VDD sky130_fd_sc_hd__fill_8
* cell instance sky130_fd_sc_hd__fill_8_1363 r0 *1 0,0
Xsky130_fd_sc_hd__fill_8_1363 VSS VDD VDD sky130_fd_sc_hd__fill_8
* cell instance sky130_fd_sc_hd__fill_8_1364 r0 *1 0,0
Xsky130_fd_sc_hd__fill_8_1364 VSS VDD VDD sky130_fd_sc_hd__fill_8
* cell instance sky130_fd_sc_hd__fill_8_1365 r0 *1 0,0
Xsky130_fd_sc_hd__fill_8_1365 VSS VDD VDD sky130_fd_sc_hd__fill_8
* cell instance sky130_fd_sc_hd__fill_8_1366 r0 *1 0,0
Xsky130_fd_sc_hd__fill_8_1366 VSS VDD VDD sky130_fd_sc_hd__fill_8
* cell instance sky130_fd_sc_hd__fill_8_1367 r0 *1 0,0
Xsky130_fd_sc_hd__fill_8_1367 VSS VDD VDD sky130_fd_sc_hd__fill_8
* cell instance sky130_fd_sc_hd__fill_8_1368 r0 *1 0,0
Xsky130_fd_sc_hd__fill_8_1368 VSS VDD VDD sky130_fd_sc_hd__fill_8
* cell instance sky130_fd_sc_hd__fill_8_1369 r0 *1 0,0
Xsky130_fd_sc_hd__fill_8_1369 VSS VDD VDD sky130_fd_sc_hd__fill_8
* cell instance sky130_fd_sc_hd__fill_8_1370 r0 *1 0,0
Xsky130_fd_sc_hd__fill_8_1370 VSS VDD VDD sky130_fd_sc_hd__fill_8
* cell instance sky130_fd_sc_hd__fill_8_1371 r0 *1 0,0
Xsky130_fd_sc_hd__fill_8_1371 VSS VDD VDD sky130_fd_sc_hd__fill_8
* cell instance sky130_fd_sc_hd__fill_8_1372 r0 *1 0,0
Xsky130_fd_sc_hd__fill_8_1372 VSS VDD VDD sky130_fd_sc_hd__fill_8
* cell instance sky130_fd_sc_hd__fill_8_1373 r0 *1 0,0
Xsky130_fd_sc_hd__fill_8_1373 VSS VDD VDD sky130_fd_sc_hd__fill_8
* cell instance sky130_fd_sc_hd__fill_8_1374 r0 *1 0,0
Xsky130_fd_sc_hd__fill_8_1374 VSS VDD VDD sky130_fd_sc_hd__fill_8
* cell instance sky130_fd_sc_hd__fill_8_1375 r0 *1 0,0
Xsky130_fd_sc_hd__fill_8_1375 VSS VDD VDD sky130_fd_sc_hd__fill_8
* cell instance sky130_fd_sc_hd__fill_8_1376 r0 *1 0,0
Xsky130_fd_sc_hd__fill_8_1376 VSS VDD VDD sky130_fd_sc_hd__fill_8
* cell instance sky130_fd_sc_hd__fill_8_1377 r0 *1 0,0
Xsky130_fd_sc_hd__fill_8_1377 VSS VDD VDD sky130_fd_sc_hd__fill_8
* cell instance sky130_fd_sc_hd__fill_8_1378 r0 *1 0,0
Xsky130_fd_sc_hd__fill_8_1378 VSS VDD VDD sky130_fd_sc_hd__fill_8
* cell instance sky130_fd_sc_hd__fill_8_1379 r0 *1 0,0
Xsky130_fd_sc_hd__fill_8_1379 VSS VDD VDD sky130_fd_sc_hd__fill_8
* cell instance sky130_fd_sc_hd__fill_8_1380 r0 *1 0,0
Xsky130_fd_sc_hd__fill_8_1380 VSS VDD VDD sky130_fd_sc_hd__fill_8
* cell instance sky130_fd_sc_hd__fill_8_1381 r0 *1 0,0
Xsky130_fd_sc_hd__fill_8_1381 VSS VDD VDD sky130_fd_sc_hd__fill_8
* cell instance sky130_fd_sc_hd__fill_8_1382 r0 *1 0,0
Xsky130_fd_sc_hd__fill_8_1382 VSS VDD VDD sky130_fd_sc_hd__fill_8
* cell instance sky130_fd_sc_hd__fill_8_1383 r0 *1 0,0
Xsky130_fd_sc_hd__fill_8_1383 VSS VDD VDD sky130_fd_sc_hd__fill_8
* cell instance sky130_fd_sc_hd__fill_8_1384 r0 *1 0,0
Xsky130_fd_sc_hd__fill_8_1384 VSS VDD VDD sky130_fd_sc_hd__fill_8
* cell instance sky130_fd_sc_hd__fill_8_1385 r0 *1 0,0
Xsky130_fd_sc_hd__fill_8_1385 VSS VDD VDD sky130_fd_sc_hd__fill_8
* cell instance sky130_fd_sc_hd__fill_8_1386 r0 *1 0,0
Xsky130_fd_sc_hd__fill_8_1386 VSS VDD VDD sky130_fd_sc_hd__fill_8
* cell instance sky130_fd_sc_hd__fill_8_1387 r0 *1 0,0
Xsky130_fd_sc_hd__fill_8_1387 VSS VDD VDD sky130_fd_sc_hd__fill_8
* cell instance sky130_fd_sc_hd__fill_8_1388 r0 *1 0,0
Xsky130_fd_sc_hd__fill_8_1388 VSS VDD VDD sky130_fd_sc_hd__fill_8
* cell instance sky130_fd_sc_hd__fill_8_1389 r0 *1 0,0
Xsky130_fd_sc_hd__fill_8_1389 VSS VDD VDD sky130_fd_sc_hd__fill_8
* cell instance sky130_fd_sc_hd__fill_8_1390 r0 *1 0,0
Xsky130_fd_sc_hd__fill_8_1390 VSS VDD VDD sky130_fd_sc_hd__fill_8
* cell instance sky130_fd_sc_hd__fill_8_1391 r0 *1 0,0
Xsky130_fd_sc_hd__fill_8_1391 VSS VDD VDD sky130_fd_sc_hd__fill_8
* cell instance sky130_fd_sc_hd__fill_8_1392 r0 *1 0,0
Xsky130_fd_sc_hd__fill_8_1392 VSS VDD VDD sky130_fd_sc_hd__fill_8
* cell instance sky130_fd_sc_hd__fill_8_1393 r0 *1 0,0
Xsky130_fd_sc_hd__fill_8_1393 VSS VDD VDD sky130_fd_sc_hd__fill_8
* cell instance sky130_fd_sc_hd__fill_8_1394 r0 *1 0,0
Xsky130_fd_sc_hd__fill_8_1394 VSS VDD VDD sky130_fd_sc_hd__fill_8
* cell instance sky130_fd_sc_hd__fill_8_1395 r0 *1 0,0
Xsky130_fd_sc_hd__fill_8_1395 VSS VDD VDD sky130_fd_sc_hd__fill_8
* cell instance sky130_fd_sc_hd__fill_8_1396 r0 *1 0,0
Xsky130_fd_sc_hd__fill_8_1396 VSS VDD VDD sky130_fd_sc_hd__fill_8
* cell instance sky130_fd_sc_hd__fill_8_1397 r0 *1 0,0
Xsky130_fd_sc_hd__fill_8_1397 VSS VDD VDD sky130_fd_sc_hd__fill_8
* cell instance sky130_fd_sc_hd__fill_8_1398 r0 *1 0,0
Xsky130_fd_sc_hd__fill_8_1398 VSS VDD VDD sky130_fd_sc_hd__fill_8
* cell instance sky130_fd_sc_hd__fill_8_1399 r0 *1 0,0
Xsky130_fd_sc_hd__fill_8_1399 VSS VDD VDD sky130_fd_sc_hd__fill_8
* cell instance sky130_fd_sc_hd__fill_8_1400 r0 *1 0,0
Xsky130_fd_sc_hd__fill_8_1400 VSS VDD VDD sky130_fd_sc_hd__fill_8
* cell instance sky130_fd_sc_hd__fill_8_1401 r0 *1 0,0
Xsky130_fd_sc_hd__fill_8_1401 VSS VDD VDD sky130_fd_sc_hd__fill_8
* cell instance sky130_fd_sc_hd__fill_8_1402 r0 *1 0,0
Xsky130_fd_sc_hd__fill_8_1402 VSS VDD VDD sky130_fd_sc_hd__fill_8
* cell instance sky130_fd_sc_hd__fill_8_1403 r0 *1 0,0
Xsky130_fd_sc_hd__fill_8_1403 VSS VDD VDD sky130_fd_sc_hd__fill_8
* cell instance sky130_fd_sc_hd__fill_8_1404 r0 *1 0,0
Xsky130_fd_sc_hd__fill_8_1404 VSS VDD VDD sky130_fd_sc_hd__fill_8
* cell instance sky130_fd_sc_hd__fill_8_1405 r0 *1 0,0
Xsky130_fd_sc_hd__fill_8_1405 VSS VDD VDD sky130_fd_sc_hd__fill_8
* cell instance sky130_fd_sc_hd__fill_8_1406 r0 *1 0,0
Xsky130_fd_sc_hd__fill_8_1406 VSS VDD VDD sky130_fd_sc_hd__fill_8
* cell instance sky130_fd_sc_hd__fill_8_1407 r0 *1 0,0
Xsky130_fd_sc_hd__fill_8_1407 VSS VDD VDD sky130_fd_sc_hd__fill_8
* cell instance sky130_fd_sc_hd__fill_8_1408 r0 *1 0,0
Xsky130_fd_sc_hd__fill_8_1408 VSS VDD VDD sky130_fd_sc_hd__fill_8
* cell instance sky130_fd_sc_hd__fill_8_1409 r0 *1 0,0
Xsky130_fd_sc_hd__fill_8_1409 VSS VDD VDD sky130_fd_sc_hd__fill_8
* cell instance sky130_fd_sc_hd__fill_8_1410 r0 *1 0,0
Xsky130_fd_sc_hd__fill_8_1410 VSS VDD VDD sky130_fd_sc_hd__fill_8
* cell instance sky130_fd_sc_hd__fill_8_1411 r0 *1 0,0
Xsky130_fd_sc_hd__fill_8_1411 VSS VDD VDD sky130_fd_sc_hd__fill_8
* cell instance sky130_fd_sc_hd__fill_8_1412 r0 *1 0,0
Xsky130_fd_sc_hd__fill_8_1412 VSS VDD VDD sky130_fd_sc_hd__fill_8
* cell instance sky130_fd_sc_hd__fill_8_1413 r0 *1 0,0
Xsky130_fd_sc_hd__fill_8_1413 VSS VDD VDD sky130_fd_sc_hd__fill_8
* cell instance sky130_fd_sc_hd__fill_8_1414 r0 *1 0,0
Xsky130_fd_sc_hd__fill_8_1414 VSS VDD VDD sky130_fd_sc_hd__fill_8
* cell instance sky130_fd_sc_hd__fill_8_1415 r0 *1 0,0
Xsky130_fd_sc_hd__fill_8_1415 VSS VDD VDD sky130_fd_sc_hd__fill_8
* cell instance sky130_fd_sc_hd__fill_8_1416 r0 *1 0,0
Xsky130_fd_sc_hd__fill_8_1416 VSS VDD VDD sky130_fd_sc_hd__fill_8
* cell instance sky130_fd_sc_hd__fill_8_1417 r0 *1 0,0
Xsky130_fd_sc_hd__fill_8_1417 VSS VDD VDD sky130_fd_sc_hd__fill_8
* cell instance sky130_fd_sc_hd__fill_8_1418 r0 *1 0,0
Xsky130_fd_sc_hd__fill_8_1418 VSS VDD VDD sky130_fd_sc_hd__fill_8
* cell instance sky130_fd_sc_hd__fill_8_1419 r0 *1 0,0
Xsky130_fd_sc_hd__fill_8_1419 VSS VDD VDD sky130_fd_sc_hd__fill_8
* cell instance sky130_fd_sc_hd__fill_8_1420 r0 *1 0,0
Xsky130_fd_sc_hd__fill_8_1420 VSS VDD VDD sky130_fd_sc_hd__fill_8
* cell instance sky130_fd_sc_hd__fill_8_1421 r0 *1 0,0
Xsky130_fd_sc_hd__fill_8_1421 VSS VDD VDD sky130_fd_sc_hd__fill_8
* cell instance sky130_fd_sc_hd__fill_8_1422 r0 *1 0,0
Xsky130_fd_sc_hd__fill_8_1422 VSS VDD VDD sky130_fd_sc_hd__fill_8
* cell instance sky130_fd_sc_hd__fill_8_1423 r0 *1 0,0
Xsky130_fd_sc_hd__fill_8_1423 VSS VDD VDD sky130_fd_sc_hd__fill_8
* cell instance sky130_fd_sc_hd__fill_8_1424 r0 *1 0,0
Xsky130_fd_sc_hd__fill_8_1424 VSS VDD VDD sky130_fd_sc_hd__fill_8
* cell instance sky130_fd_sc_hd__fill_8_1425 r0 *1 0,0
Xsky130_fd_sc_hd__fill_8_1425 VSS VDD VDD sky130_fd_sc_hd__fill_8
* cell instance sky130_fd_sc_hd__fill_8_1426 r0 *1 0,0
Xsky130_fd_sc_hd__fill_8_1426 VSS VDD VDD sky130_fd_sc_hd__fill_8
* cell instance sky130_fd_sc_hd__fill_8_1427 r0 *1 0,0
Xsky130_fd_sc_hd__fill_8_1427 VSS VDD VDD sky130_fd_sc_hd__fill_8
* cell instance sky130_fd_sc_hd__fill_8_1428 r0 *1 0,0
Xsky130_fd_sc_hd__fill_8_1428 VSS VDD VDD sky130_fd_sc_hd__fill_8
* cell instance sky130_fd_sc_hd__fill_8_1429 r0 *1 0,0
Xsky130_fd_sc_hd__fill_8_1429 VSS VDD VDD sky130_fd_sc_hd__fill_8
* cell instance sky130_fd_sc_hd__fill_8_1430 r0 *1 0,0
Xsky130_fd_sc_hd__fill_8_1430 VSS VDD VDD sky130_fd_sc_hd__fill_8
* cell instance sky130_fd_sc_hd__fill_8_1431 r0 *1 0,0
Xsky130_fd_sc_hd__fill_8_1431 VSS VDD VDD sky130_fd_sc_hd__fill_8
* cell instance sky130_fd_sc_hd__fill_8_1432 r0 *1 0,0
Xsky130_fd_sc_hd__fill_8_1432 VSS VDD VDD sky130_fd_sc_hd__fill_8
* cell instance sky130_fd_sc_hd__fill_8_1433 r0 *1 0,0
Xsky130_fd_sc_hd__fill_8_1433 VSS VDD VDD sky130_fd_sc_hd__fill_8
* cell instance sky130_fd_sc_hd__fill_8_1434 r0 *1 0,0
Xsky130_fd_sc_hd__fill_8_1434 VSS VDD VDD sky130_fd_sc_hd__fill_8
* cell instance sky130_fd_sc_hd__fill_8_1435 r0 *1 0,0
Xsky130_fd_sc_hd__fill_8_1435 VSS VDD VDD sky130_fd_sc_hd__fill_8
* cell instance sky130_fd_sc_hd__fill_8_1436 r0 *1 0,0
Xsky130_fd_sc_hd__fill_8_1436 VSS VDD VDD sky130_fd_sc_hd__fill_8
* cell instance sky130_fd_sc_hd__fill_8_1437 r0 *1 0,0
Xsky130_fd_sc_hd__fill_8_1437 VSS VDD VDD sky130_fd_sc_hd__fill_8
* cell instance sky130_fd_sc_hd__fill_8_1438 r0 *1 0,0
Xsky130_fd_sc_hd__fill_8_1438 VSS VDD VDD sky130_fd_sc_hd__fill_8
* cell instance sky130_fd_sc_hd__fill_8_1439 r0 *1 0,0
Xsky130_fd_sc_hd__fill_8_1439 VSS VDD VDD sky130_fd_sc_hd__fill_8
* cell instance sky130_fd_sc_hd__fill_8_1440 r0 *1 0,0
Xsky130_fd_sc_hd__fill_8_1440 VSS VDD VDD sky130_fd_sc_hd__fill_8
* cell instance sky130_fd_sc_hd__fill_8_1441 r0 *1 0,0
Xsky130_fd_sc_hd__fill_8_1441 VSS VDD VDD sky130_fd_sc_hd__fill_8
* cell instance sky130_fd_sc_hd__fill_8_1442 r0 *1 0,0
Xsky130_fd_sc_hd__fill_8_1442 VSS VDD VDD sky130_fd_sc_hd__fill_8
* cell instance sky130_fd_sc_hd__fill_8_1443 r0 *1 0,0
Xsky130_fd_sc_hd__fill_8_1443 VSS VDD VDD sky130_fd_sc_hd__fill_8
* cell instance sky130_fd_sc_hd__fill_8_1444 r0 *1 0,0
Xsky130_fd_sc_hd__fill_8_1444 VSS VDD VDD sky130_fd_sc_hd__fill_8
* cell instance sky130_fd_sc_hd__fill_8_1445 r0 *1 0,0
Xsky130_fd_sc_hd__fill_8_1445 VSS VDD VDD sky130_fd_sc_hd__fill_8
* cell instance sky130_fd_sc_hd__fill_8_1446 r0 *1 0,0
Xsky130_fd_sc_hd__fill_8_1446 VSS VDD VDD sky130_fd_sc_hd__fill_8
* cell instance sky130_fd_sc_hd__fill_8_1447 r0 *1 0,0
Xsky130_fd_sc_hd__fill_8_1447 VSS VDD VDD sky130_fd_sc_hd__fill_8
* cell instance sky130_fd_sc_hd__fill_8_1448 r0 *1 0,0
Xsky130_fd_sc_hd__fill_8_1448 VSS VDD VDD sky130_fd_sc_hd__fill_8
* cell instance sky130_fd_sc_hd__fill_8_1449 r0 *1 0,0
Xsky130_fd_sc_hd__fill_8_1449 VSS VDD VDD sky130_fd_sc_hd__fill_8
* cell instance sky130_fd_sc_hd__fill_8_1450 r0 *1 0,0
Xsky130_fd_sc_hd__fill_8_1450 VSS VDD VDD sky130_fd_sc_hd__fill_8
* cell instance sky130_fd_sc_hd__fill_8_1451 r0 *1 0,0
Xsky130_fd_sc_hd__fill_8_1451 VSS VDD VDD sky130_fd_sc_hd__fill_8
* cell instance sky130_fd_sc_hd__fill_8_1452 r0 *1 0,0
Xsky130_fd_sc_hd__fill_8_1452 VSS VDD VDD sky130_fd_sc_hd__fill_8
* cell instance sky130_fd_sc_hd__fill_8_1453 r0 *1 0,0
Xsky130_fd_sc_hd__fill_8_1453 VSS VDD VDD sky130_fd_sc_hd__fill_8
* cell instance sky130_fd_sc_hd__fill_8_1454 r0 *1 0,0
Xsky130_fd_sc_hd__fill_8_1454 VSS VDD VDD sky130_fd_sc_hd__fill_8
* cell instance sky130_fd_sc_hd__fill_8_1455 r0 *1 0,0
Xsky130_fd_sc_hd__fill_8_1455 VSS VDD VDD sky130_fd_sc_hd__fill_8
* cell instance sky130_fd_sc_hd__fill_8_1456 r0 *1 0,0
Xsky130_fd_sc_hd__fill_8_1456 VSS VDD VDD sky130_fd_sc_hd__fill_8
* cell instance sky130_fd_sc_hd__fill_8_1457 r0 *1 0,0
Xsky130_fd_sc_hd__fill_8_1457 VSS VDD VDD sky130_fd_sc_hd__fill_8
* cell instance sky130_fd_sc_hd__fill_8_1458 r0 *1 0,0
Xsky130_fd_sc_hd__fill_8_1458 VSS VDD VDD sky130_fd_sc_hd__fill_8
* cell instance sky130_fd_sc_hd__fill_8_1459 r0 *1 0,0
Xsky130_fd_sc_hd__fill_8_1459 VSS VDD VDD sky130_fd_sc_hd__fill_8
* cell instance sky130_fd_sc_hd__fill_8_1460 r0 *1 0,0
Xsky130_fd_sc_hd__fill_8_1460 VSS VDD VDD sky130_fd_sc_hd__fill_8
* cell instance sky130_fd_sc_hd__fill_8_1461 r0 *1 0,0
Xsky130_fd_sc_hd__fill_8_1461 VSS VDD VDD sky130_fd_sc_hd__fill_8
* cell instance sky130_fd_sc_hd__fill_8_1462 r0 *1 0,0
Xsky130_fd_sc_hd__fill_8_1462 VSS VDD VDD sky130_fd_sc_hd__fill_8
* cell instance sky130_fd_sc_hd__fill_8_1463 r0 *1 0,0
Xsky130_fd_sc_hd__fill_8_1463 VSS VDD VDD sky130_fd_sc_hd__fill_8
* cell instance sky130_fd_sc_hd__fill_8_1464 r0 *1 0,0
Xsky130_fd_sc_hd__fill_8_1464 VSS VDD VDD sky130_fd_sc_hd__fill_8
* cell instance sky130_fd_sc_hd__fill_8_1465 r0 *1 0,0
Xsky130_fd_sc_hd__fill_8_1465 VSS VDD VDD sky130_fd_sc_hd__fill_8
* cell instance sky130_fd_sc_hd__fill_8_1466 r0 *1 0,0
Xsky130_fd_sc_hd__fill_8_1466 VSS VDD VDD sky130_fd_sc_hd__fill_8
* cell instance sky130_fd_sc_hd__fill_8_1467 r0 *1 0,0
Xsky130_fd_sc_hd__fill_8_1467 VSS VDD VDD sky130_fd_sc_hd__fill_8
* cell instance sky130_fd_sc_hd__fill_8_1468 r0 *1 0,0
Xsky130_fd_sc_hd__fill_8_1468 VSS VDD VDD sky130_fd_sc_hd__fill_8
* cell instance sky130_fd_sc_hd__fill_8_1469 r0 *1 0,0
Xsky130_fd_sc_hd__fill_8_1469 VSS VDD VDD sky130_fd_sc_hd__fill_8
* cell instance sky130_fd_sc_hd__fill_8_1470 r0 *1 0,0
Xsky130_fd_sc_hd__fill_8_1470 VSS VDD VDD sky130_fd_sc_hd__fill_8
* cell instance sky130_fd_sc_hd__fill_8_1471 r0 *1 0,0
Xsky130_fd_sc_hd__fill_8_1471 VSS VDD VDD sky130_fd_sc_hd__fill_8
* cell instance sky130_fd_sc_hd__fill_8_1472 r0 *1 0,0
Xsky130_fd_sc_hd__fill_8_1472 VSS VDD VDD sky130_fd_sc_hd__fill_8
* cell instance sky130_fd_sc_hd__fill_8_1473 r0 *1 0,0
Xsky130_fd_sc_hd__fill_8_1473 VSS VDD VDD sky130_fd_sc_hd__fill_8
* cell instance sky130_fd_sc_hd__fill_8_1474 r0 *1 0,0
Xsky130_fd_sc_hd__fill_8_1474 VSS VDD VDD sky130_fd_sc_hd__fill_8
* cell instance sky130_fd_sc_hd__fill_8_1475 r0 *1 0,0
Xsky130_fd_sc_hd__fill_8_1475 VSS VDD VDD sky130_fd_sc_hd__fill_8
* cell instance sky130_fd_sc_hd__fill_8_1476 r0 *1 0,0
Xsky130_fd_sc_hd__fill_8_1476 VSS VDD VDD sky130_fd_sc_hd__fill_8
* cell instance sky130_fd_sc_hd__fill_8_1477 r0 *1 0,0
Xsky130_fd_sc_hd__fill_8_1477 VSS VDD VDD sky130_fd_sc_hd__fill_8
* cell instance sky130_fd_sc_hd__fill_8_1478 r0 *1 0,0
Xsky130_fd_sc_hd__fill_8_1478 VSS VDD VDD sky130_fd_sc_hd__fill_8
* cell instance sky130_fd_sc_hd__fill_8_1479 r0 *1 0,0
Xsky130_fd_sc_hd__fill_8_1479 VSS VDD VDD sky130_fd_sc_hd__fill_8
* cell instance sky130_fd_sc_hd__fill_8_1480 r0 *1 0,0
Xsky130_fd_sc_hd__fill_8_1480 VSS VDD VDD sky130_fd_sc_hd__fill_8
* cell instance sky130_fd_sc_hd__fill_8_1481 r0 *1 0,0
Xsky130_fd_sc_hd__fill_8_1481 VSS VDD VDD sky130_fd_sc_hd__fill_8
* cell instance sky130_fd_sc_hd__fill_8_1482 r0 *1 0,0
Xsky130_fd_sc_hd__fill_8_1482 VSS VDD VDD sky130_fd_sc_hd__fill_8
* cell instance sky130_fd_sc_hd__fill_8_1483 r0 *1 0,0
Xsky130_fd_sc_hd__fill_8_1483 VSS VDD VDD sky130_fd_sc_hd__fill_8
* cell instance sky130_fd_sc_hd__fill_8_1484 r0 *1 0,0
Xsky130_fd_sc_hd__fill_8_1484 VSS VDD VDD sky130_fd_sc_hd__fill_8
* cell instance sky130_fd_sc_hd__fill_8_1485 r0 *1 0,0
Xsky130_fd_sc_hd__fill_8_1485 VSS VDD VDD sky130_fd_sc_hd__fill_8
* cell instance sky130_fd_sc_hd__fill_8_1486 r0 *1 0,0
Xsky130_fd_sc_hd__fill_8_1486 VSS VDD VDD sky130_fd_sc_hd__fill_8
* cell instance sky130_fd_sc_hd__fill_8_1487 r0 *1 0,0
Xsky130_fd_sc_hd__fill_8_1487 VSS VDD VDD sky130_fd_sc_hd__fill_8
* cell instance sky130_fd_sc_hd__fill_8_1488 r0 *1 0,0
Xsky130_fd_sc_hd__fill_8_1488 VSS VDD VDD sky130_fd_sc_hd__fill_8
* cell instance sky130_fd_sc_hd__fill_8_1489 r0 *1 0,0
Xsky130_fd_sc_hd__fill_8_1489 VSS VDD VDD sky130_fd_sc_hd__fill_8
* cell instance sky130_fd_sc_hd__fill_8_1490 r0 *1 0,0
Xsky130_fd_sc_hd__fill_8_1490 VSS VDD VDD sky130_fd_sc_hd__fill_8
* cell instance sky130_fd_sc_hd__fill_8_1491 r0 *1 0,0
Xsky130_fd_sc_hd__fill_8_1491 VSS VDD VDD sky130_fd_sc_hd__fill_8
* cell instance sky130_fd_sc_hd__fill_8_1492 r0 *1 0,0
Xsky130_fd_sc_hd__fill_8_1492 VSS VDD VDD sky130_fd_sc_hd__fill_8
* cell instance sky130_fd_sc_hd__fill_8_1493 r0 *1 0,0
Xsky130_fd_sc_hd__fill_8_1493 VSS VDD VDD sky130_fd_sc_hd__fill_8
* cell instance sky130_fd_sc_hd__fill_8_1494 r0 *1 0,0
Xsky130_fd_sc_hd__fill_8_1494 VSS VDD VDD sky130_fd_sc_hd__fill_8
* cell instance sky130_fd_sc_hd__fill_8_1495 r0 *1 0,0
Xsky130_fd_sc_hd__fill_8_1495 VSS VDD VDD sky130_fd_sc_hd__fill_8
* cell instance sky130_fd_sc_hd__fill_8_1496 r0 *1 0,0
Xsky130_fd_sc_hd__fill_8_1496 VSS VDD VDD sky130_fd_sc_hd__fill_8
* cell instance sky130_fd_sc_hd__fill_8_1497 r0 *1 0,0
Xsky130_fd_sc_hd__fill_8_1497 VSS VDD VDD sky130_fd_sc_hd__fill_8
* cell instance sky130_fd_sc_hd__fill_8_1498 r0 *1 0,0
Xsky130_fd_sc_hd__fill_8_1498 VSS VDD VDD sky130_fd_sc_hd__fill_8
* cell instance sky130_fd_sc_hd__fill_8_1499 r0 *1 0,0
Xsky130_fd_sc_hd__fill_8_1499 VSS VDD VDD sky130_fd_sc_hd__fill_8
* cell instance sky130_fd_sc_hd__fill_8_1500 r0 *1 0,0
Xsky130_fd_sc_hd__fill_8_1500 VSS VDD VDD sky130_fd_sc_hd__fill_8
* cell instance sky130_fd_sc_hd__fill_8_1501 r0 *1 0,0
Xsky130_fd_sc_hd__fill_8_1501 VSS VDD VDD sky130_fd_sc_hd__fill_8
* cell instance sky130_fd_sc_hd__fill_8_1502 r0 *1 0,0
Xsky130_fd_sc_hd__fill_8_1502 VSS VDD VDD sky130_fd_sc_hd__fill_8
* cell instance sky130_fd_sc_hd__inv_1_0 r0 *1 0,0
Xsky130_fd_sc_hd__inv_1_0 clknet_leaf_0_clk_ref VSS VDD VDD \$2387
+ sky130_fd_sc_hd__inv_1
* cell instance sky130_fd_sc_hd__inv_1_1 r0 *1 0,0
Xsky130_fd_sc_hd__inv_1_1 clknet_leaf_37_clk_ref VSS VDD VDD \$181
+ sky130_fd_sc_hd__inv_1
* cell instance sky130_fd_sc_hd__inv_1_2 r0 *1 0,0
Xsky130_fd_sc_hd__inv_1_2 clknet_leaf_39_clk_ref VSS VDD VDD \$1044
+ sky130_fd_sc_hd__inv_1
* cell instance sky130_fd_sc_hd__inv_1_3 r0 *1 0,0
Xsky130_fd_sc_hd__inv_1_3 clknet_leaf_10_clk_ref VSS VDD VDD \$4606
+ sky130_fd_sc_hd__inv_1
* cell instance sky130_fd_sc_hd__inv_1_4 r0 *1 0,0
Xsky130_fd_sc_hd__inv_1_4 busy_r VSS VDD VDD \_0449_ sky130_fd_sc_hd__inv_1
* cell instance sky130_fd_sc_hd__inv_1_5 r0 *1 0,0
Xsky130_fd_sc_hd__inv_1_5 clknet_leaf_4_clk_ref VSS VDD VDD \$3304
+ sky130_fd_sc_hd__inv_1
* cell instance sky130_fd_sc_hd__inv_1_6 r0 *1 0,0
Xsky130_fd_sc_hd__inv_1_6 ovf_o VSS VDD VDD \_0452_ sky130_fd_sc_hd__inv_1
* cell instance sky130_fd_sc_hd__inv_1_7 r0 *1 0,0
Xsky130_fd_sc_hd__inv_1_7 clknet_leaf_14_clk_ref VSS VDD VDD \$3554
+ sky130_fd_sc_hd__inv_1
* cell instance sky130_fd_sc_hd__inv_1_8 r0 *1 0,0
Xsky130_fd_sc_hd__inv_1_8 clknet_leaf_12_clk_ref VSS VDD VDD \$4731
+ sky130_fd_sc_hd__inv_1
* cell instance sky130_fd_sc_hd__inv_1_9 r0 *1 0,0
Xsky130_fd_sc_hd__inv_1_9 clknet_leaf_34_clk_ref VSS VDD VDD \$842
+ sky130_fd_sc_hd__inv_1
* cell instance sky130_fd_sc_hd__inv_1_10 r0 *1 0,0
Xsky130_fd_sc_hd__inv_1_10 clknet_leaf_32_clk_ref VSS VDD VDD \$1839
+ sky130_fd_sc_hd__inv_1
* cell instance sky130_fd_sc_hd__inv_1_11 r0 *1 0,0
Xsky130_fd_sc_hd__inv_1_11 \_0373_ VSS VDD VDD \_0387_ sky130_fd_sc_hd__inv_1
* cell instance sky130_fd_sc_hd__inv_1_12 r0 *1 0,0
Xsky130_fd_sc_hd__inv_1_12 clknet_leaf_15_clk_ref VSS VDD VDD \$2937
+ sky130_fd_sc_hd__inv_1
* cell instance sky130_fd_sc_hd__inv_1_13 r0 *1 0,0
Xsky130_fd_sc_hd__inv_1_13 \_0377_ VSS VDD VDD \_0388_ sky130_fd_sc_hd__inv_1
* cell instance sky130_fd_sc_hd__inv_1_14 r0 *1 0,0
Xsky130_fd_sc_hd__inv_1_14 clknet_leaf_31_clk_ref VSS VDD VDD \$916
+ sky130_fd_sc_hd__inv_1
* cell instance sky130_fd_sc_hd__inv_1_15 r0 *1 0,0
Xsky130_fd_sc_hd__inv_1_15 gate_cnt[2] VSS VDD VDD \_0757_
+ sky130_fd_sc_hd__inv_1
* cell instance sky130_fd_sc_hd__inv_1_16 r0 *1 0,0
Xsky130_fd_sc_hd__inv_1_16 gate_cnt[22] VSS VDD VDD \_0767_
+ sky130_fd_sc_hd__inv_1
* cell instance sky130_fd_sc_hd__inv_1_17 r0 *1 0,0
Xsky130_fd_sc_hd__inv_1_17 cnt_o[22] VSS VDD VDD u_cnt/_081_
+ sky130_fd_sc_hd__inv_1
* cell instance sky130_fd_sc_hd__inv_1_18 r0 *1 0,0
Xsky130_fd_sc_hd__inv_1_18 cnt_o[21] VSS VDD VDD u_cnt/_080_
+ sky130_fd_sc_hd__inv_1
* cell instance sky130_fd_sc_hd__inv_1_19 r0 *1 0,0
Xsky130_fd_sc_hd__inv_1_19 clknet_leaf_29_clk_ref VSS VDD VDD \$281
+ sky130_fd_sc_hd__inv_1
* cell instance sky130_fd_sc_hd__inv_1_20 r0 *1 0,0
Xsky130_fd_sc_hd__inv_1_20 gate_cnt[29] VSS VDD VDD \_0701_
+ sky130_fd_sc_hd__inv_1
* cell instance sky130_fd_sc_hd__inv_1_21 r0 *1 0,0
Xsky130_fd_sc_hd__inv_1_21 u_cnt/gate_s2 VSS VDD VDD u_cnt/_083_
+ sky130_fd_sc_hd__inv_1
* cell instance sky130_fd_sc_hd__inv_1_22 r0 *1 0,0
Xsky130_fd_sc_hd__inv_1_22 cnt_o[17] VSS VDD VDD u_cnt/_034_
+ sky130_fd_sc_hd__inv_1
* cell instance sky130_fd_sc_hd__inv_1_23 r0 *1 0,0
Xsky130_fd_sc_hd__inv_1_23 clknet_leaf_23_clk_ref VSS VDD VDD \$3100
+ sky130_fd_sc_hd__inv_1
* cell instance sky130_fd_sc_hd__inv_1_24 r0 *1 0,0
Xsky130_fd_sc_hd__inv_1_24 cnt_o[19] VSS VDD VDD u_cnt/_028_
+ sky130_fd_sc_hd__inv_1
* cell instance sky130_fd_sc_hd__inv_1_25 r0 *1 0,0
Xsky130_fd_sc_hd__inv_1_25 cnt_o[23] VSS VDD VDD u_cnt/_045_
+ sky130_fd_sc_hd__inv_1
* cell instance sky130_fd_sc_hd__inv_1_26 r0 *1 0,0
Xsky130_fd_sc_hd__inv_1_26 cnt_o[6] VSS VDD VDD u_cnt/_071_
+ sky130_fd_sc_hd__inv_1
* cell instance sky130_fd_sc_hd__inv_1_27 r0 *1 0,0
Xsky130_fd_sc_hd__inv_1_27 cnt_o[7] VSS VDD VDD u_cnt/_072_
+ sky130_fd_sc_hd__inv_1
* cell instance sky130_fd_sc_hd__inv_1_28 r0 *1 0,0
Xsky130_fd_sc_hd__inv_1_28 cnt_o[10] VSS VDD VDD u_cnt/_052_
+ sky130_fd_sc_hd__inv_1
* cell instance sky130_fd_sc_hd__inv_1_29 r0 *1 0,0
Xsky130_fd_sc_hd__inv_1_29 cnt_o[12] VSS VDD VDD u_cnt/_070_
+ sky130_fd_sc_hd__inv_1
* cell instance sky130_fd_sc_hd__inv_1_30 r0 *1 0,0
Xsky130_fd_sc_hd__inv_1_30 u_cnt/_046_ VSS VDD VDD u_cnt/_047_
+ sky130_fd_sc_hd__inv_1
* cell instance sky130_fd_sc_hd__inv_1_31 r0 *1 0,0
Xsky130_fd_sc_hd__inv_1_31 clknet_leaf_22_clk_ref VSS VDD VDD \$3107
+ sky130_fd_sc_hd__inv_1
* cell instance sky130_fd_sc_hd__inv_1_32 r0 *1 0,0
Xsky130_fd_sc_hd__inv_1_32 cnt_o[11] VSS VDD VDD u_cnt/_069_
+ sky130_fd_sc_hd__inv_1
* cell instance sky130_fd_sc_hd__inv_1_33 r0 *1 0,0
Xsky130_fd_sc_hd__inv_1_33 cnt_o[8] VSS VDD VDD u_cnt/_057_
+ sky130_fd_sc_hd__inv_1
* cell instance sky130_fd_sc_hd__inv_1_34 r0 *1 0,0
Xsky130_fd_sc_hd__inv_1_34 clknet_leaf_19_clk_ref VSS VDD VDD \$4269
+ sky130_fd_sc_hd__inv_1
* cell instance sky130_fd_sc_hd__inv_1_35 r0 *1 0,0
Xsky130_fd_sc_hd__inv_1_35 clknet_leaf_27_clk_ref VSS VDD VDD \$1189
+ sky130_fd_sc_hd__inv_1
* cell instance sky130_fd_sc_hd__inv_1_36 r0 *1 0,0
Xsky130_fd_sc_hd__inv_1_36 clknet_leaf_21_clk_ref VSS VDD VDD \$2911
+ sky130_fd_sc_hd__inv_1
* cell instance sky130_fd_sc_hd__mux2_2_0 r0 *1 0,0
Xsky130_fd_sc_hd__mux2_2_0 wdata[13] cal_r[1][13] \_0440_ VSS VDD VDD \_0196_
+ sky130_fd_sc_hd__mux2_2
* cell instance sky130_fd_sc_hd__mux2_2_1 r0 *1 0,0
Xsky130_fd_sc_hd__mux2_2_1 wdata[12] cal_r[1][12] \_0440_ VSS VDD VDD \_0197_
+ sky130_fd_sc_hd__mux2_2
* cell instance sky130_fd_sc_hd__mux2_2_2 r0 *1 0,0
Xsky130_fd_sc_hd__mux2_2_2 wdata[17] cal_r[1][17] \_0440_ VSS VDD VDD \_0192_
+ sky130_fd_sc_hd__mux2_2
* cell instance sky130_fd_sc_hd__mux2_2_3 r0 *1 0,0
Xsky130_fd_sc_hd__mux2_2_3 wdata[15] cal_r[0][15] \_0339_ VSS VDD VDD \_0289_
+ sky130_fd_sc_hd__mux2_2
* cell instance sky130_fd_sc_hd__mux2_2_4 r0 *1 0,0
Xsky130_fd_sc_hd__mux2_2_4 wdata[22] cal_r[1][22] \_0440_ VSS VDD VDD \_0187_
+ sky130_fd_sc_hd__mux2_2
* cell instance sky130_fd_sc_hd__mux2_2_5 r0 *1 0,0
Xsky130_fd_sc_hd__mux2_2_5 wdata[19] cal_r[1][19] \_0440_ VSS VDD VDD \_0190_
+ sky130_fd_sc_hd__mux2_2
* cell instance sky130_fd_sc_hd__mux2_2_6 r0 *1 0,0
Xsky130_fd_sc_hd__mux2_2_6 wdata[23] cal_r[2][23] net11 VSS VDD VDD \_0270_
+ sky130_fd_sc_hd__mux2_2
* cell instance sky130_fd_sc_hd__mux2_2_7 r0 *1 0,0
Xsky130_fd_sc_hd__mux2_2_7 wdata[13] cal_r[0][13] \_0339_ VSS VDD VDD \_0291_
+ sky130_fd_sc_hd__mux2_2
* cell instance sky130_fd_sc_hd__mux2_2_8 r0 *1 0,0
Xsky130_fd_sc_hd__mux2_2_8 wdata[0] cal_r[1][0] \_0440_ VSS VDD VDD \_0225_
+ sky130_fd_sc_hd__mux2_2
* cell instance sky130_fd_sc_hd__mux2_2_9 r0 *1 0,0
Xsky130_fd_sc_hd__mux2_2_9 wdata[23] cal_r[0][23] \_0339_ VSS VDD VDD \_0206_
+ sky130_fd_sc_hd__mux2_2
* cell instance sky130_fd_sc_hd__mux2_2_10 r0 *1 0,0
Xsky130_fd_sc_hd__mux2_2_10 wdata[20] cal_r[3][20] \_0365_ VSS VDD VDD \_0135_
+ sky130_fd_sc_hd__mux2_2
* cell instance sky130_fd_sc_hd__mux2_2_11 r0 *1 0,0
Xsky130_fd_sc_hd__mux2_2_11 wdata[12] cal_r[0][12] \_0339_ VSS VDD VDD \_0001_
+ sky130_fd_sc_hd__mux2_2
* cell instance sky130_fd_sc_hd__mux2_2_12 r0 *1 0,0
Xsky130_fd_sc_hd__mux2_2_12 wdata[17] cal_r[0][17] \_0339_ VSS VDD VDD \_0287_
+ sky130_fd_sc_hd__mux2_2
* cell instance sky130_fd_sc_hd__mux2_2_13 r0 *1 0,0
Xsky130_fd_sc_hd__mux2_2_13 wdata[1] cal_r[0][1] \_0339_ VSS VDD VDD \_0012_
+ sky130_fd_sc_hd__mux2_2
* cell instance sky130_fd_sc_hd__mux2_2_14 r0 *1 0,0
Xsky130_fd_sc_hd__mux2_2_14 wdata[19] cal_r[0][19] \_0339_ VSS VDD VDD \_0285_
+ sky130_fd_sc_hd__mux2_2
* cell instance sky130_fd_sc_hd__mux2_2_15 r0 *1 0,0
Xsky130_fd_sc_hd__mux2_2_15 wdata[15] cal_r[2][15] net11 VSS VDD VDD \_0092_
+ sky130_fd_sc_hd__mux2_2
* cell instance sky130_fd_sc_hd__mux2_2_16 r0 *1 0,0
Xsky130_fd_sc_hd__mux2_2_16 wdata[22] cal_r[3][22] \_0365_ VSS VDD VDD \_0133_
+ sky130_fd_sc_hd__mux2_2
* cell instance sky130_fd_sc_hd__mux2_2_17 r0 *1 0,0
Xsky130_fd_sc_hd__mux2_2_17 wdata[12] cal_r[4][12] net10 VSS VDD VDD \_0236_
+ sky130_fd_sc_hd__mux2_2
* cell instance sky130_fd_sc_hd__mux2_2_18 r0 *1 0,0
Xsky130_fd_sc_hd__mux2_2_18 wdata[1] cal_r[3][1] \_0365_ VSS VDD VDD \_0154_
+ sky130_fd_sc_hd__mux2_2
* cell instance sky130_fd_sc_hd__mux2_2_19 r0 *1 0,0
Xsky130_fd_sc_hd__mux2_2_19 wdata[15] cal_r[3][15] \_0365_ VSS VDD VDD \_0140_
+ sky130_fd_sc_hd__mux2_2
* cell instance sky130_fd_sc_hd__mux2_2_20 r0 *1 0,0
Xsky130_fd_sc_hd__mux2_2_20 wdata[19] cal_r[4][19] net10 VSS VDD VDD \_0229_
+ sky130_fd_sc_hd__mux2_2
* cell instance sky130_fd_sc_hd__mux2_2_21 r0 *1 0,0
Xsky130_fd_sc_hd__mux2_2_21 wdata[23] cal_r[1][23] \_0440_ VSS VDD VDD \_0214_
+ sky130_fd_sc_hd__mux2_2
* cell instance sky130_fd_sc_hd__mux2_2_22 r0 *1 0,0
Xsky130_fd_sc_hd__mux2_2_22 wdata[12] cal_r[2][12] net11 VSS VDD VDD \_0095_
+ sky130_fd_sc_hd__mux2_2
* cell instance sky130_fd_sc_hd__mux2_2_23 r0 *1 0,0
Xsky130_fd_sc_hd__mux2_2_23 wdata[0] cal_r[2][0] net11 VSS VDD VDD \_0107_
+ sky130_fd_sc_hd__mux2_2
* cell instance sky130_fd_sc_hd__mux2_2_24 r0 *1 0,0
Xsky130_fd_sc_hd__mux2_2_24 wdata[17] cal_r[2][17] net11 VSS VDD VDD \_0090_
+ sky130_fd_sc_hd__mux2_2
* cell instance sky130_fd_sc_hd__mux2_2_25 r0 *1 0,0
Xsky130_fd_sc_hd__mux2_2_25 wdata[19] cal_r[2][19] net11 VSS VDD VDD \_0088_
+ sky130_fd_sc_hd__mux2_2
* cell instance sky130_fd_sc_hd__mux2_2_26 r0 *1 0,0
Xsky130_fd_sc_hd__mux2_2_26 wdata[22] cal_r[2][22] net11 VSS VDD VDD \_0108_
+ sky130_fd_sc_hd__mux2_2
* cell instance sky130_fd_sc_hd__mux2_2_27 r0 *1 0,0
Xsky130_fd_sc_hd__mux2_2_27 wdata[23] cal_r[3][23] \_0365_ VSS VDD VDD \_0220_
+ sky130_fd_sc_hd__mux2_2
* cell instance sky130_fd_sc_hd__mux2_2_28 r0 *1 0,0
Xsky130_fd_sc_hd__mux2_2_28 wdata[17] cal_r[4][17] net10 VSS VDD VDD \_0231_
+ sky130_fd_sc_hd__mux2_2
* cell instance sky130_fd_sc_hd__mux2_2_29 r0 *1 0,0
Xsky130_fd_sc_hd__mux2_2_29 wdata[22] cal_r[0][22] \_0339_ VSS VDD VDD \_0282_
+ sky130_fd_sc_hd__mux2_2
* cell instance sky130_fd_sc_hd__mux2_2_30 r0 *1 0,0
Xsky130_fd_sc_hd__mux2_2_30 wdata[13] cal_r[2][13] net11 VSS VDD VDD \_0094_
+ sky130_fd_sc_hd__mux2_2
* cell instance sky130_fd_sc_hd__mux2_2_31 r0 *1 0,0
Xsky130_fd_sc_hd__mux2_2_31 wdata[19] cal_r[3][19] \_0365_ VSS VDD VDD \_0136_
+ sky130_fd_sc_hd__mux2_2
* cell instance sky130_fd_sc_hd__mux2_2_32 r0 *1 0,0
Xsky130_fd_sc_hd__mux2_2_32 wdata[15] cal_r[1][15] \_0440_ VSS VDD VDD \_0194_
+ sky130_fd_sc_hd__mux2_2
* cell instance sky130_fd_sc_hd__mux2_2_33 r0 *1 0,0
Xsky130_fd_sc_hd__mux2_2_33 wdata[13] cal_r[3][13] \_0365_ VSS VDD VDD \_0142_
+ sky130_fd_sc_hd__mux2_2
* cell instance sky130_fd_sc_hd__mux2_2_34 r0 *1 0,0
Xsky130_fd_sc_hd__mux2_2_34 wdata[12] cal_r[3][12] \_0365_ VSS VDD VDD \_0143_
+ sky130_fd_sc_hd__mux2_2
* cell instance sky130_fd_sc_hd__mux2_2_35 r0 *1 0,0
Xsky130_fd_sc_hd__mux2_2_35 wdata[17] cal_r[3][17] \_0365_ VSS VDD VDD \_0138_
+ sky130_fd_sc_hd__mux2_2
* cell instance sky130_fd_sc_hd__mux2_2_36 r0 *1 0,0
Xsky130_fd_sc_hd__mux2_2_36 wdata[22] cal_r[4][22] net10 VSS VDD VDD \_0226_
+ sky130_fd_sc_hd__mux2_2
* cell instance sky130_fd_sc_hd__mux2_2_37 r0 *1 0,0
Xsky130_fd_sc_hd__mux2_2_37 wdata[15] cal_r[4][15] net10 VSS VDD VDD \_0233_
+ sky130_fd_sc_hd__mux2_2
* cell instance sky130_fd_sc_hd__mux2_2_38 r0 *1 0,0
Xsky130_fd_sc_hd__mux2_2_38 wdata[23] cal_r[4][23] \_0450_ VSS VDD VDD \_0213_
+ sky130_fd_sc_hd__mux2_2
* cell instance sky130_fd_sc_hd__mux2_2_39 r0 *1 0,0
Xsky130_fd_sc_hd__mux2_2_39 wdata[13] cal_r[4][13] \_0450_ VSS VDD VDD \_0235_
+ sky130_fd_sc_hd__mux2_2
* cell instance sky130_fd_sc_hd__mux2_2_40 r0 *1 0,0
Xsky130_fd_sc_hd__mux2_2_40 wdata[0] cal_r[4][0] net10 VSS VDD VDD \_0248_
+ sky130_fd_sc_hd__mux2_2
* cell instance sky130_fd_sc_hd__mux2_2_41 r0 *1 0,0
Xsky130_fd_sc_hd__mux2_2_41 wdata[20] cal_r[4][20] \_0450_ VSS VDD VDD \_0228_
+ sky130_fd_sc_hd__mux2_2
* cell instance sky130_fd_sc_hd__mux2_2_42 r0 *1 0,0
Xsky130_fd_sc_hd__mux2_2_42 wdata[18] cal_r[2][18] net11 VSS VDD VDD \_0089_
+ sky130_fd_sc_hd__mux2_2
* cell instance sky130_fd_sc_hd__mux2_2_43 r0 *1 0,0
Xsky130_fd_sc_hd__mux2_2_43 wdata[0] cal_r[3][0] \_0365_ VSS VDD VDD \_0155_
+ sky130_fd_sc_hd__mux2_2
* cell instance sky130_fd_sc_hd__mux2_2_44 r0 *1 0,0
Xsky130_fd_sc_hd__mux2_2_44 wdata[1] cal_r[2][1] net11 VSS VDD VDD \_0106_
+ sky130_fd_sc_hd__mux2_2
* cell instance sky130_fd_sc_hd__mux2_2_45 r0 *1 0,0
Xsky130_fd_sc_hd__mux2_2_45 wdata[10] cal_r[0][10] \_0339_ VSS VDD VDD \_0003_
+ sky130_fd_sc_hd__mux2_2
* cell instance sky130_fd_sc_hd__mux2_2_46 r0 *1 0,0
Xsky130_fd_sc_hd__mux2_2_46 wdata[1] cal_r[1][1] \_0440_ VSS VDD VDD \_0224_
+ sky130_fd_sc_hd__mux2_2
* cell instance sky130_fd_sc_hd__mux2_2_47 r0 *1 0,0
Xsky130_fd_sc_hd__mux2_2_47 wdata[10] cal_r[1][10] \_0440_ VSS VDD VDD \_0199_
+ sky130_fd_sc_hd__mux2_2
* cell instance sky130_fd_sc_hd__mux2_2_48 r0 *1 0,0
Xsky130_fd_sc_hd__mux2_2_48 wdata[14] cal_r[2][14] net11 VSS VDD VDD \_0093_
+ sky130_fd_sc_hd__mux2_2
* cell instance sky130_fd_sc_hd__mux2_2_49 r0 *1 0,0
Xsky130_fd_sc_hd__mux2_2_49 wdata[2] cal_r[0][2] \_0339_ VSS VDD VDD \_0011_
+ sky130_fd_sc_hd__mux2_2
* cell instance sky130_fd_sc_hd__mux2_2_50 r0 *1 0,0
Xsky130_fd_sc_hd__mux2_2_50 wdata[10] cal_r[2][10] net11 VSS VDD VDD \_0097_
+ sky130_fd_sc_hd__mux2_2
* cell instance sky130_fd_sc_hd__mux2_2_51 r0 *1 0,0
Xsky130_fd_sc_hd__mux2_2_51 wdata[20] cal_r[2][20] \_0359_ VSS VDD VDD \_0087_
+ sky130_fd_sc_hd__mux2_2
* cell instance sky130_fd_sc_hd__mux2_2_52 r0 *1 0,0
Xsky130_fd_sc_hd__mux2_2_52 wdata[18] cal_r[1][18] \_0440_ VSS VDD VDD \_0191_
+ sky130_fd_sc_hd__mux2_2
* cell instance sky130_fd_sc_hd__mux2_2_53 r0 *1 0,0
Xsky130_fd_sc_hd__mux2_2_53 wdata[14] cal_r[3][14] \_0365_ VSS VDD VDD \_0141_
+ sky130_fd_sc_hd__mux2_2
* cell instance sky130_fd_sc_hd__mux2_2_54 r0 *1 0,0
Xsky130_fd_sc_hd__mux2_2_54 wdata[14] cal_r[0][14] \_0339_ VSS VDD VDD \_0290_
+ sky130_fd_sc_hd__mux2_2
* cell instance sky130_fd_sc_hd__mux2_2_55 r0 *1 0,0
Xsky130_fd_sc_hd__mux2_2_55 wdata[20] cal_r[0][20] \_0339_ VSS VDD VDD \_0284_
+ sky130_fd_sc_hd__mux2_2
* cell instance sky130_fd_sc_hd__mux2_2_56 r0 *1 0,0
Xsky130_fd_sc_hd__mux2_2_56 wdata[1] ctrl_sel[0] \_0313_ VSS VDD VDD \_0086_
+ sky130_fd_sc_hd__mux2_2
* cell instance sky130_fd_sc_hd__mux2_2_57 r0 *1 0,0
Xsky130_fd_sc_hd__mux2_2_57 wdata[18] cal_r[3][18] \_0365_ VSS VDD VDD \_0137_
+ sky130_fd_sc_hd__mux2_2
* cell instance sky130_fd_sc_hd__mux2_2_58 r0 *1 0,0
Xsky130_fd_sc_hd__mux2_2_58 wdata[0] cal_r[0][0] \_0339_ VSS VDD VDD \_0013_
+ sky130_fd_sc_hd__mux2_2
* cell instance sky130_fd_sc_hd__mux2_2_59 r0 *1 0,0
Xsky130_fd_sc_hd__mux2_2_59 wdata[10] cal_r[4][10] net10 VSS VDD VDD \_0238_
+ sky130_fd_sc_hd__mux2_2
* cell instance sky130_fd_sc_hd__mux2_2_60 r0 *1 0,0
Xsky130_fd_sc_hd__mux2_2_60 wdata[18] cal_r[0][18] \_0339_ VSS VDD VDD \_0286_
+ sky130_fd_sc_hd__mux2_2
* cell instance sky130_fd_sc_hd__mux2_2_61 r0 *1 0,0
Xsky130_fd_sc_hd__mux2_2_61 wdata[18] cal_r[4][18] net10 VSS VDD VDD \_0230_
+ sky130_fd_sc_hd__mux2_2
* cell instance sky130_fd_sc_hd__mux2_2_62 r0 *1 0,0
Xsky130_fd_sc_hd__mux2_2_62 wdata[10] cal_r[3][10] \_0365_ VSS VDD VDD \_0145_
+ sky130_fd_sc_hd__mux2_2
* cell instance sky130_fd_sc_hd__mux2_2_63 r0 *1 0,0
Xsky130_fd_sc_hd__mux2_2_63 wdata[20] cal_r[1][20] \_0440_ VSS VDD VDD \_0189_
+ sky130_fd_sc_hd__mux2_2
* cell instance sky130_fd_sc_hd__mux2_2_64 r0 *1 0,0
Xsky130_fd_sc_hd__mux2_2_64 wdata[21] cal_r[0][21] \_0339_ VSS VDD VDD \_0283_
+ sky130_fd_sc_hd__mux2_2
* cell instance sky130_fd_sc_hd__mux2_2_65 r0 *1 0,0
Xsky130_fd_sc_hd__mux2_2_65 wdata[2] cal_r[1][2] \_0440_ VSS VDD VDD \_0223_
+ sky130_fd_sc_hd__mux2_2
* cell instance sky130_fd_sc_hd__mux2_2_66 r0 *1 0,0
Xsky130_fd_sc_hd__mux2_2_66 wdata[21] cal_r[1][21] \_0440_ VSS VDD VDD \_0188_
+ sky130_fd_sc_hd__mux2_2
* cell instance sky130_fd_sc_hd__mux2_2_67 r0 *1 0,0
Xsky130_fd_sc_hd__mux2_2_67 wdata[1] cal_r[4][1] net10 VSS VDD VDD \_0247_
+ sky130_fd_sc_hd__mux2_2
* cell instance sky130_fd_sc_hd__mux2_2_68 r0 *1 0,0
Xsky130_fd_sc_hd__mux2_2_68 wdata[14] cal_r[4][14] \_0450_ VSS VDD VDD \_0234_
+ sky130_fd_sc_hd__mux2_2
* cell instance sky130_fd_sc_hd__mux2_2_69 r0 *1 0,0
Xsky130_fd_sc_hd__mux2_2_69 wdata[14] cal_r[1][14] \_0440_ VSS VDD VDD \_0195_
+ sky130_fd_sc_hd__mux2_2
* cell instance sky130_fd_sc_hd__mux2_2_70 r0 *1 0,0
Xsky130_fd_sc_hd__mux2_2_70 wdata[2] cal_r[3][2] \_0365_ VSS VDD VDD \_0153_
+ sky130_fd_sc_hd__mux2_2
* cell instance sky130_fd_sc_hd__mux2_2_71 r0 *1 0,0
Xsky130_fd_sc_hd__mux2_2_71 wdata[2] cal_r[2][2] net11 VSS VDD VDD \_0105_
+ sky130_fd_sc_hd__mux2_2
* cell instance sky130_fd_sc_hd__mux2_2_72 r0 *1 0,0
Xsky130_fd_sc_hd__mux2_2_72 wdata[4] cal_r[3][4] \_0365_ VSS VDD VDD \_0151_
+ sky130_fd_sc_hd__mux2_2
* cell instance sky130_fd_sc_hd__mux2_2_73 r0 *1 0,0
Xsky130_fd_sc_hd__mux2_2_73 wdata[11] cal_r[2][11] net11 VSS VDD VDD \_0096_
+ sky130_fd_sc_hd__mux2_2
* cell instance sky130_fd_sc_hd__mux2_2_74 r0 *1 0,0
Xsky130_fd_sc_hd__mux2_2_74 wdata[16] cal_r[2][16] \_0359_ VSS VDD VDD \_0091_
+ sky130_fd_sc_hd__mux2_2
* cell instance sky130_fd_sc_hd__mux2_2_75 r0 *1 0,0
Xsky130_fd_sc_hd__mux2_2_75 wdata[16] cal_r[3][16] \_0365_ VSS VDD VDD \_0139_
+ sky130_fd_sc_hd__mux2_2
* cell instance sky130_fd_sc_hd__mux2_2_76 r0 *1 0,0
Xsky130_fd_sc_hd__mux2_2_76 wdata[4] cal_r[2][4] net11 VSS VDD VDD \_0103_
+ sky130_fd_sc_hd__mux2_2
* cell instance sky130_fd_sc_hd__mux2_2_77 r0 *1 0,0
Xsky130_fd_sc_hd__mux2_2_77 wdata[2] ctrl_sel[1] \_0313_ VSS VDD VDD \_0085_
+ sky130_fd_sc_hd__mux2_2
* cell instance sky130_fd_sc_hd__mux2_2_78 r0 *1 0,0
Xsky130_fd_sc_hd__mux2_2_78 wdata[2] cal_r[4][2] net10 VSS VDD VDD \_0246_
+ sky130_fd_sc_hd__mux2_2
* cell instance sky130_fd_sc_hd__mux2_2_79 r0 *1 0,0
Xsky130_fd_sc_hd__mux2_2_79 wdata[9] cal_r[4][9] \_0450_ VSS VDD VDD \_0239_
+ sky130_fd_sc_hd__mux2_2
* cell instance sky130_fd_sc_hd__mux2_2_80 r0 *1 0,0
Xsky130_fd_sc_hd__mux2_2_80 wdata[21] cal_r[3][21] \_0365_ VSS VDD VDD \_0134_
+ sky130_fd_sc_hd__mux2_2
* cell instance sky130_fd_sc_hd__mux2_2_81 r0 *1 0,0
Xsky130_fd_sc_hd__mux2_2_81 wdata[4] cal_r[0][4] \_0339_ VSS VDD VDD \_0009_
+ sky130_fd_sc_hd__mux2_2
* cell instance sky130_fd_sc_hd__mux2_2_82 r0 *1 0,0
Xsky130_fd_sc_hd__mux2_2_82 wdata[11] cal_r[0][11] \_0339_ VSS VDD VDD \_0002_
+ sky130_fd_sc_hd__mux2_2
* cell instance sky130_fd_sc_hd__mux2_2_83 r0 *1 0,0
Xsky130_fd_sc_hd__mux2_2_83 wdata[11] cal_r[3][11] \_0365_ VSS VDD VDD \_0144_
+ sky130_fd_sc_hd__mux2_2
* cell instance sky130_fd_sc_hd__mux2_2_84 r0 *1 0,0
Xsky130_fd_sc_hd__mux2_2_84 wdata[16] cal_r[1][16] \_0440_ VSS VDD VDD \_0193_
+ sky130_fd_sc_hd__mux2_2
* cell instance sky130_fd_sc_hd__mux2_2_85 r0 *1 0,0
Xsky130_fd_sc_hd__mux2_2_85 wdata[5] ctrl_k[1] \_0313_ VSS VDD VDD \_0276_
+ sky130_fd_sc_hd__mux2_2
* cell instance sky130_fd_sc_hd__mux2_2_86 r0 *1 0,0
Xsky130_fd_sc_hd__mux2_2_86 wdata[9] cal_r[1][9] \_0440_ VSS VDD VDD \_0202_
+ sky130_fd_sc_hd__mux2_2
* cell instance sky130_fd_sc_hd__mux2_2_87 r0 *1 0,0
Xsky130_fd_sc_hd__mux2_2_87 wdata[11] cal_r[1][11] \_0440_ VSS VDD VDD \_0198_
+ sky130_fd_sc_hd__mux2_2
* cell instance sky130_fd_sc_hd__mux2_2_88 r0 *1 0,0
Xsky130_fd_sc_hd__mux2_2_88 wdata[9] cal_r[2][9] \_0359_ VSS VDD VDD \_0098_
+ sky130_fd_sc_hd__mux2_2
* cell instance sky130_fd_sc_hd__mux2_2_89 r0 *1 0,0
Xsky130_fd_sc_hd__mux2_2_89 wdata[3] cal_r[1][3] \_0440_ VSS VDD VDD \_0222_
+ sky130_fd_sc_hd__mux2_2
* cell instance sky130_fd_sc_hd__mux2_2_90 r0 *1 0,0
Xsky130_fd_sc_hd__mux2_2_90 wdata[4] cal_r[1][4] \_0440_ VSS VDD VDD \_0221_
+ sky130_fd_sc_hd__mux2_2
* cell instance sky130_fd_sc_hd__mux2_2_91 r0 *1 0,0
Xsky130_fd_sc_hd__mux2_2_91 wdata[9] cal_r[3][9] \_0365_ VSS VDD VDD \_0146_
+ sky130_fd_sc_hd__mux2_2
* cell instance sky130_fd_sc_hd__mux2_2_92 r0 *1 0,0
Xsky130_fd_sc_hd__mux2_2_92 wdata[16] cal_r[4][16] \_0450_ VSS VDD VDD \_0232_
+ sky130_fd_sc_hd__mux2_2
* cell instance sky130_fd_sc_hd__mux2_2_93 r0 *1 0,0
Xsky130_fd_sc_hd__mux2_2_93 wdata[16] cal_r[0][16] \_0339_ VSS VDD VDD \_0288_
+ sky130_fd_sc_hd__mux2_2
* cell instance sky130_fd_sc_hd__mux2_2_94 r0 *1 0,0
Xsky130_fd_sc_hd__mux2_2_94 wdata[3] ctrl_sel[2] \_0313_ VSS VDD VDD \_0200_
+ sky130_fd_sc_hd__mux2_2
* cell instance sky130_fd_sc_hd__mux2_2_95 r0 *1 0,0
Xsky130_fd_sc_hd__mux2_2_95 wdata[4] cal_r[4][4] net10 VSS VDD VDD \_0244_
+ sky130_fd_sc_hd__mux2_2
* cell instance sky130_fd_sc_hd__mux2_2_96 r0 *1 0,0
Xsky130_fd_sc_hd__mux2_2_96 wdata[11] cal_r[4][11] net10 VSS VDD VDD \_0237_
+ sky130_fd_sc_hd__mux2_2
* cell instance sky130_fd_sc_hd__mux2_2_97 r0 *1 0,0
Xsky130_fd_sc_hd__mux2_2_97 wdata[21] cal_r[4][21] \_0450_ VSS VDD VDD \_0227_
+ sky130_fd_sc_hd__mux2_2
* cell instance sky130_fd_sc_hd__mux2_2_98 r0 *1 0,0
Xsky130_fd_sc_hd__mux2_2_98 wdata[5] cal_r[2][5] \_0359_ VSS VDD VDD \_0102_
+ sky130_fd_sc_hd__mux2_2
* cell instance sky130_fd_sc_hd__mux2_2_99 r0 *1 0,0
Xsky130_fd_sc_hd__mux2_2_99 wdata[21] cal_r[2][21] \_0359_ VSS VDD VDD \_0109_
+ sky130_fd_sc_hd__mux2_2
* cell instance sky130_fd_sc_hd__mux2_2_100 r0 *1 0,0
Xsky130_fd_sc_hd__mux2_2_100 wdata[3] cal_r[0][3] \_0339_ VSS VDD VDD \_0010_
+ sky130_fd_sc_hd__mux2_2
* cell instance sky130_fd_sc_hd__mux2_2_101 r0 *1 0,0
Xsky130_fd_sc_hd__mux2_2_101 wdata[6] cal_r[2][6] net11 VSS VDD VDD \_0101_
+ sky130_fd_sc_hd__mux2_2
* cell instance sky130_fd_sc_hd__mux2_2_102 r0 *1 0,0
Xsky130_fd_sc_hd__mux2_2_102 wdata[9] cal_r[0][9] \_0339_ VSS VDD VDD \_0004_
+ sky130_fd_sc_hd__mux2_2
* cell instance sky130_fd_sc_hd__mux2_2_103 r0 *1 0,0
Xsky130_fd_sc_hd__mux2_2_103 wdata[5] cal_r[4][5] \_0450_ VSS VDD VDD \_0243_
+ sky130_fd_sc_hd__mux2_2
* cell instance sky130_fd_sc_hd__mux2_2_104 r0 *1 0,0
Xsky130_fd_sc_hd__mux2_2_104 wdata[6] cal_r[0][6] \_0339_ VSS VDD VDD \_0007_
+ sky130_fd_sc_hd__mux2_2
* cell instance sky130_fd_sc_hd__mux2_2_105 r0 *1 0,0
Xsky130_fd_sc_hd__mux2_2_105 wdata[7] cal_r[3][7] \_0365_ VSS VDD VDD \_0148_
+ sky130_fd_sc_hd__mux2_2
* cell instance sky130_fd_sc_hd__mux2_2_106 r0 *1 0,0
Xsky130_fd_sc_hd__mux2_2_106 wdata[5] cal_r[0][5] \_0339_ VSS VDD VDD \_0008_
+ sky130_fd_sc_hd__mux2_2
* cell instance sky130_fd_sc_hd__mux2_2_107 r0 *1 0,0
Xsky130_fd_sc_hd__mux2_2_107 wdata[7] cal_r[0][7] \_0339_ VSS VDD VDD \_0006_
+ sky130_fd_sc_hd__mux2_2
* cell instance sky130_fd_sc_hd__mux2_2_108 r0 *1 0,0
Xsky130_fd_sc_hd__mux2_2_108 wdata[8] cal_r[0][8] \_0339_ VSS VDD VDD \_0005_
+ sky130_fd_sc_hd__mux2_2
* cell instance sky130_fd_sc_hd__mux2_2_109 r0 *1 0,0
Xsky130_fd_sc_hd__mux2_2_109 wdata[8] cal_r[2][8] net11 VSS VDD VDD \_0099_
+ sky130_fd_sc_hd__mux2_2
* cell instance sky130_fd_sc_hd__mux2_2_110 r0 *1 0,0
Xsky130_fd_sc_hd__mux2_2_110 cnt_o[21] count_r[1][21] \_0356_ VSS VDD VDD
+ \_0063_ sky130_fd_sc_hd__mux2_2
* cell instance sky130_fd_sc_hd__mux2_2_111 r0 *1 0,0
Xsky130_fd_sc_hd__mux2_2_111 cnt_o[20] count_r[1][20] \_0356_ VSS VDD VDD
+ \_0064_ sky130_fd_sc_hd__mux2_2
* cell instance sky130_fd_sc_hd__mux2_2_112 r0 *1 0,0
Xsky130_fd_sc_hd__mux2_2_112 wdata[6] ctrl_k[2] \_0313_ VSS VDD VDD \_0275_
+ sky130_fd_sc_hd__mux2_2
* cell instance sky130_fd_sc_hd__mux2_2_113 r0 *1 0,0
Xsky130_fd_sc_hd__mux2_2_113 wdata[7] cal_r[2][7] net11 VSS VDD VDD \_0100_
+ sky130_fd_sc_hd__mux2_2
* cell instance sky130_fd_sc_hd__mux2_2_114 r0 *1 0,0
Xsky130_fd_sc_hd__mux2_2_114 wdata[5] cal_r[1][5] \_0440_ VSS VDD VDD \_0218_
+ sky130_fd_sc_hd__mux2_2
* cell instance sky130_fd_sc_hd__mux2_2_115 r0 *1 0,0
Xsky130_fd_sc_hd__mux2_2_115 cnt_o[16] count_r[1][16] \_0356_ VSS VDD VDD
+ \_0068_ sky130_fd_sc_hd__mux2_2
* cell instance sky130_fd_sc_hd__mux2_2_116 r0 *1 0,0
Xsky130_fd_sc_hd__mux2_2_116 cnt_o[21] count_r[0][21] \_0447_ VSS VDD VDD
+ \_0250_ sky130_fd_sc_hd__mux2_2
* cell instance sky130_fd_sc_hd__mux2_2_117 r0 *1 0,0
Xsky130_fd_sc_hd__mux2_2_117 wdata[3] cal_r[2][3] net11 VSS VDD VDD \_0104_
+ sky130_fd_sc_hd__mux2_2
* cell instance sky130_fd_sc_hd__mux2_2_118 r0 *1 0,0
Xsky130_fd_sc_hd__mux2_2_118 wdata[7] cal_r[4][7] net10 VSS VDD VDD \_0241_
+ sky130_fd_sc_hd__mux2_2
* cell instance sky130_fd_sc_hd__mux2_2_119 r0 *1 0,0
Xsky130_fd_sc_hd__mux2_2_119 cnt_o[16] count_r[0][16] \_0447_ VSS VDD VDD
+ \_0255_ sky130_fd_sc_hd__mux2_2
* cell instance sky130_fd_sc_hd__mux2_2_120 r0 *1 0,0
Xsky130_fd_sc_hd__mux2_2_120 cnt_o[20] count_r[0][20] \_0447_ VSS VDD VDD
+ \_0251_ sky130_fd_sc_hd__mux2_2
* cell instance sky130_fd_sc_hd__mux2_2_121 r0 *1 0,0
Xsky130_fd_sc_hd__mux2_2_121 wdata[5] cal_r[3][5] \_0365_ VSS VDD VDD \_0150_
+ sky130_fd_sc_hd__mux2_2
* cell instance sky130_fd_sc_hd__mux2_2_122 r0 *1 0,0
Xsky130_fd_sc_hd__mux2_2_122 wdata[8] cal_r[1][8] \_0440_ VSS VDD VDD \_0211_
+ sky130_fd_sc_hd__mux2_2
* cell instance sky130_fd_sc_hd__mux2_2_123 r0 *1 0,0
Xsky130_fd_sc_hd__mux2_2_123 cnt_o[17] count_r[0][17] \_0447_ VSS VDD VDD
+ \_0254_ sky130_fd_sc_hd__mux2_2
* cell instance sky130_fd_sc_hd__mux2_2_124 r0 *1 0,0
Xsky130_fd_sc_hd__mux2_2_124 wdata[7] cal_r[1][7] \_0440_ VSS VDD VDD \_0216_
+ sky130_fd_sc_hd__mux2_2
* cell instance sky130_fd_sc_hd__mux2_2_125 r0 *1 0,0
Xsky130_fd_sc_hd__mux2_2_125 wdata[7] ctrl_k[3] \_0313_ VSS VDD VDD \_0274_
+ sky130_fd_sc_hd__mux2_2
* cell instance sky130_fd_sc_hd__mux2_2_126 r0 *1 0,0
Xsky130_fd_sc_hd__mux2_2_126 wdata[6] cal_r[1][6] \_0440_ VSS VDD VDD \_0217_
+ sky130_fd_sc_hd__mux2_2
* cell instance sky130_fd_sc_hd__mux2_2_127 r0 *1 0,0
Xsky130_fd_sc_hd__mux2_2_127 cnt_o[16] count_r[3][16] net12 VSS VDD VDD \_0045_
+ sky130_fd_sc_hd__mux2_2
* cell instance sky130_fd_sc_hd__mux2_2_128 r0 *1 0,0
Xsky130_fd_sc_hd__mux2_2_128 wdata[8] cal_r[4][8] net10 VSS VDD VDD \_0240_
+ sky130_fd_sc_hd__mux2_2
* cell instance sky130_fd_sc_hd__mux2_2_129 r0 *1 0,0
Xsky130_fd_sc_hd__mux2_2_129 cnt_o[16] count_r[2][16] \_0344_ VSS VDD VDD
+ \_0020_ sky130_fd_sc_hd__mux2_2
* cell instance sky130_fd_sc_hd__mux2_2_130 r0 *1 0,0
Xsky130_fd_sc_hd__mux2_2_130 wdata[6] cal_r[3][6] \_0365_ VSS VDD VDD \_0149_
+ sky130_fd_sc_hd__mux2_2
* cell instance sky130_fd_sc_hd__mux2_2_131 r0 *1 0,0
Xsky130_fd_sc_hd__mux2_2_131 cnt_o[16] count_r[4][16] \_0362_ VSS VDD VDD
+ \_0116_ sky130_fd_sc_hd__mux2_2
* cell instance sky130_fd_sc_hd__mux2_2_132 r0 *1 0,0
Xsky130_fd_sc_hd__mux2_2_132 cnt_o[17] count_r[1][17] \_0356_ VSS VDD VDD
+ \_0067_ sky130_fd_sc_hd__mux2_2
* cell instance sky130_fd_sc_hd__mux2_2_133 r0 *1 0,0
Xsky130_fd_sc_hd__mux2_2_133 wdata[8] cal_r[3][8] \_0365_ VSS VDD VDD \_0147_
+ sky130_fd_sc_hd__mux2_2
* cell instance sky130_fd_sc_hd__mux2_2_134 r0 *1 0,0
Xsky130_fd_sc_hd__mux2_2_134 cnt_o[17] count_r[3][17] net12 VSS VDD VDD \_0044_
+ sky130_fd_sc_hd__mux2_2
* cell instance sky130_fd_sc_hd__mux2_2_135 r0 *1 0,0
Xsky130_fd_sc_hd__mux2_2_135 wdata[3] cal_r[3][3] \_0365_ VSS VDD VDD \_0152_
+ sky130_fd_sc_hd__mux2_2
* cell instance sky130_fd_sc_hd__mux2_2_136 r0 *1 0,0
Xsky130_fd_sc_hd__mux2_2_136 cnt_o[17] count_r[2][17] \_0344_ VSS VDD VDD
+ \_0019_ sky130_fd_sc_hd__mux2_2
* cell instance sky130_fd_sc_hd__mux2_2_137 r0 *1 0,0
Xsky130_fd_sc_hd__mux2_2_137 wdata[4] ctrl_k[0] \_0313_ VSS VDD VDD \_0277_
+ sky130_fd_sc_hd__mux2_2
* cell instance sky130_fd_sc_hd__mux2_2_138 r0 *1 0,0
Xsky130_fd_sc_hd__mux2_2_138 cnt_o[18] count_r[3][18] net12 VSS VDD VDD \_0043_
+ sky130_fd_sc_hd__mux2_2
* cell instance sky130_fd_sc_hd__mux2_2_139 r0 *1 0,0
Xsky130_fd_sc_hd__mux2_2_139 wdata[8] ctrl_k[4] \_0313_ VSS VDD VDD \_0208_
+ sky130_fd_sc_hd__mux2_2
* cell instance sky130_fd_sc_hd__mux2_2_140 r0 *1 0,0
Xsky130_fd_sc_hd__mux2_2_140 cnt_o[20] count_r[4][20] \_0362_ VSS VDD VDD
+ \_0112_ sky130_fd_sc_hd__mux2_2
* cell instance sky130_fd_sc_hd__mux2_2_141 r0 *1 0,0
Xsky130_fd_sc_hd__mux2_2_141 cnt_o[1] count_r[1][1] \_0356_ VSS VDD VDD \_0083_
+ sky130_fd_sc_hd__mux2_2
* cell instance sky130_fd_sc_hd__mux2_2_142 r0 *1 0,0
Xsky130_fd_sc_hd__mux2_2_142 cnt_o[0] count_r[1][0] \_0356_ VSS VDD VDD \_0084_
+ sky130_fd_sc_hd__mux2_2
* cell instance sky130_fd_sc_hd__mux2_2_143 r0 *1 0,0
Xsky130_fd_sc_hd__mux2_2_143 cnt_o[1] count_r[3][1] net12 VSS VDD VDD \_0060_
+ sky130_fd_sc_hd__mux2_2
* cell instance sky130_fd_sc_hd__mux2_2_144 r0 *1 0,0
Xsky130_fd_sc_hd__mux2_2_144 wdata[3] cal_r[4][3] net10 VSS VDD VDD \_0245_
+ sky130_fd_sc_hd__mux2_2
* cell instance sky130_fd_sc_hd__mux2_2_145 r0 *1 0,0
Xsky130_fd_sc_hd__mux2_2_145 wdata[6] cal_r[4][6] net10 VSS VDD VDD \_0242_
+ sky130_fd_sc_hd__mux2_2
* cell instance sky130_fd_sc_hd__mux2_2_146 r0 *1 0,0
Xsky130_fd_sc_hd__mux2_2_146 cnt_o[18] count_r[0][18] \_0447_ VSS VDD VDD
+ \_0253_ sky130_fd_sc_hd__mux2_2
* cell instance sky130_fd_sc_hd__mux2_2_147 r0 *1 0,0
Xsky130_fd_sc_hd__mux2_2_147 cnt_o[20] count_r[3][20] net12 VSS VDD VDD \_0041_
+ sky130_fd_sc_hd__mux2_2
* cell instance sky130_fd_sc_hd__mux2_2_148 r0 *1 0,0
Xsky130_fd_sc_hd__mux2_2_148 cnt_o[0] count_r[4][0] \_0362_ VSS VDD VDD \_0132_
+ sky130_fd_sc_hd__mux2_2
* cell instance sky130_fd_sc_hd__mux2_2_149 r0 *1 0,0
Xsky130_fd_sc_hd__mux2_2_149 cnt_o[21] count_r[2][21] \_0344_ VSS VDD VDD
+ \_0015_ sky130_fd_sc_hd__mux2_2
* cell instance sky130_fd_sc_hd__mux2_2_150 r0 *1 0,0
Xsky130_fd_sc_hd__mux2_2_150 cnt_o[0] count_r[2][0] \_0344_ VSS VDD VDD \_0036_
+ sky130_fd_sc_hd__mux2_2
* cell instance sky130_fd_sc_hd__mux2_2_151 r0 *1 0,0
Xsky130_fd_sc_hd__mux2_2_151 cnt_o[21] count_r[3][21] net12 VSS VDD VDD \_0040_
+ sky130_fd_sc_hd__mux2_2
* cell instance sky130_fd_sc_hd__mux2_2_152 r0 *1 0,0
Xsky130_fd_sc_hd__mux2_2_152 cnt_o[18] count_r[1][18] \_0356_ VSS VDD VDD
+ \_0066_ sky130_fd_sc_hd__mux2_2
* cell instance sky130_fd_sc_hd__mux2_2_153 r0 *1 0,0
Xsky130_fd_sc_hd__mux2_2_153 cnt_o[17] count_r[4][17] \_0362_ VSS VDD VDD
+ \_0115_ sky130_fd_sc_hd__mux2_2
* cell instance sky130_fd_sc_hd__mux2_2_154 r0 *1 0,0
Xsky130_fd_sc_hd__mux2_2_154 cnt_o[18] count_r[2][18] \_0344_ VSS VDD VDD
+ \_0018_ sky130_fd_sc_hd__mux2_2
* cell instance sky130_fd_sc_hd__mux2_2_155 r0 *1 0,0
Xsky130_fd_sc_hd__mux2_2_155 cnt_o[1] count_r[4][1] \_0362_ VSS VDD VDD \_0131_
+ sky130_fd_sc_hd__mux2_2
* cell instance sky130_fd_sc_hd__mux2_2_156 r0 *1 0,0
Xsky130_fd_sc_hd__mux2_2_156 cnt_o[21] count_r[4][21] \_0362_ VSS VDD VDD
+ \_0111_ sky130_fd_sc_hd__mux2_2
* cell instance sky130_fd_sc_hd__mux2_2_157 r0 *1 0,0
Xsky130_fd_sc_hd__mux2_2_157 cnt_o[18] count_r[4][18] \_0362_ VSS VDD VDD
+ \_0114_ sky130_fd_sc_hd__mux2_2
* cell instance sky130_fd_sc_hd__mux2_2_158 r0 *1 0,0
Xsky130_fd_sc_hd__mux2_2_158 cnt_o[1] count_r[2][1] \_0344_ VSS VDD VDD \_0035_
+ sky130_fd_sc_hd__mux2_2
* cell instance sky130_fd_sc_hd__mux2_2_159 r0 *1 0,0
Xsky130_fd_sc_hd__mux2_2_159 cnt_o[12] count_r[2][12] \_0344_ VSS VDD VDD
+ \_0024_ sky130_fd_sc_hd__mux2_2
* cell instance sky130_fd_sc_hd__mux2_2_160 r0 *1 0,0
Xsky130_fd_sc_hd__mux2_2_160 cnt_o[12] count_r[0][12] \_0447_ VSS VDD VDD
+ \_0259_ sky130_fd_sc_hd__mux2_2
* cell instance sky130_fd_sc_hd__mux2_2_161 r0 *1 0,0
Xsky130_fd_sc_hd__mux2_2_161 cnt_o[20] count_r[2][20] \_0344_ VSS VDD VDD
+ \_0016_ sky130_fd_sc_hd__mux2_2
* cell instance sky130_fd_sc_hd__mux2_2_162 r0 *1 0,0
Xsky130_fd_sc_hd__mux2_2_162 cnt_o[1] count_r[0][1] \_0447_ VSS VDD VDD \_0272_
+ sky130_fd_sc_hd__mux2_2
* cell instance sky130_fd_sc_hd__mux2_2_163 r0 *1 0,0
Xsky130_fd_sc_hd__mux2_2_163 cnt_o[10] count_r[4][10] \_0362_ VSS VDD VDD
+ \_0122_ sky130_fd_sc_hd__mux2_2
* cell instance sky130_fd_sc_hd__mux2_2_164 r0 *1 0,0
Xsky130_fd_sc_hd__mux2_2_164 cnt_o[10] count_r[3][10] net12 VSS VDD VDD \_0051_
+ sky130_fd_sc_hd__mux2_2
* cell instance sky130_fd_sc_hd__mux2_2_165 r0 *1 0,0
Xsky130_fd_sc_hd__mux2_2_165 cnt_o[22] count_r[2][22] \_0344_ VSS VDD VDD
+ \_0014_ sky130_fd_sc_hd__mux2_2
* cell instance sky130_fd_sc_hd__mux2_2_166 r0 *1 0,0
Xsky130_fd_sc_hd__mux2_2_166 cnt_o[0] count_r[3][0] net12 VSS VDD VDD \_0061_
+ sky130_fd_sc_hd__mux2_2
* cell instance sky130_fd_sc_hd__mux2_2_167 r0 *1 0,0
Xsky130_fd_sc_hd__mux2_2_167 cnt_o[14] count_r[4][14] \_0362_ VSS VDD VDD
+ \_0118_ sky130_fd_sc_hd__mux2_2
* cell instance sky130_fd_sc_hd__mux2_2_168 r0 *1 0,0
Xsky130_fd_sc_hd__mux2_2_168 cnt_o[22] count_r[3][22] net12 VSS VDD VDD \_0039_
+ sky130_fd_sc_hd__mux2_2
* cell instance sky130_fd_sc_hd__mux2_2_169 r0 *1 0,0
Xsky130_fd_sc_hd__mux2_2_169 cnt_o[14] count_r[2][14] \_0344_ VSS VDD VDD
+ \_0022_ sky130_fd_sc_hd__mux2_2
* cell instance sky130_fd_sc_hd__mux2_2_170 r0 *1 0,0
Xsky130_fd_sc_hd__mux2_2_170 cnt_o[10] count_r[1][10] \_0356_ VSS VDD VDD
+ \_0074_ sky130_fd_sc_hd__mux2_2
* cell instance sky130_fd_sc_hd__mux2_2_171 r0 *1 0,0
Xsky130_fd_sc_hd__mux2_2_171 cnt_o[14] count_r[0][14] \_0447_ VSS VDD VDD
+ \_0257_ sky130_fd_sc_hd__mux2_2
* cell instance sky130_fd_sc_hd__mux2_2_172 r0 *1 0,0
Xsky130_fd_sc_hd__mux2_2_172 cnt_o[22] count_r[4][22] \_0362_ VSS VDD VDD
+ \_0110_ sky130_fd_sc_hd__mux2_2
* cell instance sky130_fd_sc_hd__mux2_2_173 r0 *1 0,0
Xsky130_fd_sc_hd__mux2_2_173 cnt_o[22] count_r[0][22] \_0447_ VSS VDD VDD
+ \_0249_ sky130_fd_sc_hd__mux2_2
* cell instance sky130_fd_sc_hd__mux2_2_174 r0 *1 0,0
Xsky130_fd_sc_hd__mux2_2_174 cnt_o[12] count_r[1][12] \_0356_ VSS VDD VDD
+ \_0072_ sky130_fd_sc_hd__mux2_2
* cell instance sky130_fd_sc_hd__mux2_2_175 r0 *1 0,0
Xsky130_fd_sc_hd__mux2_2_175 cnt_o[0] count_r[0][0] \_0447_ VSS VDD VDD \_0273_
+ sky130_fd_sc_hd__mux2_2
* cell instance sky130_fd_sc_hd__mux2_2_176 r0 *1 0,0
Xsky130_fd_sc_hd__mux2_2_176 cnt_o[2] count_r[4][2] \_0362_ VSS VDD VDD \_0130_
+ sky130_fd_sc_hd__mux2_2
* cell instance sky130_fd_sc_hd__mux2_2_177 r0 *1 0,0
Xsky130_fd_sc_hd__mux2_2_177 cnt_o[14] count_r[3][14] net12 VSS VDD VDD \_0047_
+ sky130_fd_sc_hd__mux2_2
* cell instance sky130_fd_sc_hd__mux2_2_178 r0 *1 0,0
Xsky130_fd_sc_hd__mux2_2_178 cnt_o[12] count_r[3][12] net12 VSS VDD VDD \_0049_
+ sky130_fd_sc_hd__mux2_2
* cell instance sky130_fd_sc_hd__mux2_2_179 r0 *1 0,0
Xsky130_fd_sc_hd__mux2_2_179 cnt_o[2] count_r[0][2] \_0447_ VSS VDD VDD \_0271_
+ sky130_fd_sc_hd__mux2_2
* cell instance sky130_fd_sc_hd__mux2_2_180 r0 *1 0,0
Xsky130_fd_sc_hd__mux2_2_180 cnt_o[10] count_r[2][10] \_0344_ VSS VDD VDD
+ \_0026_ sky130_fd_sc_hd__mux2_2
* cell instance sky130_fd_sc_hd__mux2_2_181 r0 *1 0,0
Xsky130_fd_sc_hd__mux2_2_181 cnt_o[14] count_r[1][14] \_0356_ VSS VDD VDD
+ \_0070_ sky130_fd_sc_hd__mux2_2
* cell instance sky130_fd_sc_hd__mux2_2_182 r0 *1 0,0
Xsky130_fd_sc_hd__mux2_2_182 cnt_o[2] count_r[1][2] \_0356_ VSS VDD VDD \_0082_
+ sky130_fd_sc_hd__mux2_2
* cell instance sky130_fd_sc_hd__mux2_2_183 r0 *1 0,0
Xsky130_fd_sc_hd__mux2_2_183 cnt_o[12] count_r[4][12] \_0362_ VSS VDD VDD
+ \_0120_ sky130_fd_sc_hd__mux2_2
* cell instance sky130_fd_sc_hd__mux2_2_184 r0 *1 0,0
Xsky130_fd_sc_hd__mux2_2_184 cnt_o[22] count_r[1][22] \_0356_ VSS VDD VDD
+ \_0062_ sky130_fd_sc_hd__mux2_2
* cell instance sky130_fd_sc_hd__mux2_2_185 r0 *1 0,0
Xsky130_fd_sc_hd__mux2_2_185 cnt_o[15] count_r[3][15] net12 VSS VDD VDD \_0046_
+ sky130_fd_sc_hd__mux2_2
* cell instance sky130_fd_sc_hd__mux2_2_186 r0 *1 0,0
Xsky130_fd_sc_hd__mux2_2_186 cnt_o[15] count_r[4][15] \_0362_ VSS VDD VDD
+ \_0117_ sky130_fd_sc_hd__mux2_2
* cell instance sky130_fd_sc_hd__mux2_2_187 r0 *1 0,0
Xsky130_fd_sc_hd__mux2_2_187 cnt_o[2] count_r[2][2] \_0344_ VSS VDD VDD \_0034_
+ sky130_fd_sc_hd__mux2_2
* cell instance sky130_fd_sc_hd__mux2_2_188 r0 *1 0,0
Xsky130_fd_sc_hd__mux2_2_188 cnt_o[2] count_r[3][2] net12 VSS VDD VDD \_0059_
+ sky130_fd_sc_hd__mux2_2
* cell instance sky130_fd_sc_hd__mux2_2_189 r0 *1 0,0
Xsky130_fd_sc_hd__mux2_2_189 cnt_o[15] count_r[1][15] \_0356_ VSS VDD VDD
+ \_0069_ sky130_fd_sc_hd__mux2_2
* cell instance sky130_fd_sc_hd__mux2_2_190 r0 *1 0,0
Xsky130_fd_sc_hd__mux2_2_190 cnt_o[15] count_r[2][15] \_0344_ VSS VDD VDD
+ \_0021_ sky130_fd_sc_hd__mux2_2
* cell instance sky130_fd_sc_hd__mux2_2_191 r0 *1 0,0
Xsky130_fd_sc_hd__mux2_2_191 cnt_o[10] count_r[0][10] \_0447_ VSS VDD VDD
+ \_0261_ sky130_fd_sc_hd__mux2_2
* cell instance sky130_fd_sc_hd__mux2_2_192 r0 *1 0,0
Xsky130_fd_sc_hd__mux2_2_192 cnt_o[15] count_r[0][15] \_0447_ VSS VDD VDD
+ \_0256_ sky130_fd_sc_hd__mux2_2
* cell instance sky130_fd_sc_hd__mux2_2_193 r0 *1 0,0
Xsky130_fd_sc_hd__mux2_2_193 cnt_o[7] count_r[1][7] \_0356_ VSS VDD VDD \_0077_
+ sky130_fd_sc_hd__mux2_2
* cell instance sky130_fd_sc_hd__mux2_2_194 r0 *1 0,0
Xsky130_fd_sc_hd__mux2_2_194 cnt_o[7] count_r[2][7] \_0344_ VSS VDD VDD \_0029_
+ sky130_fd_sc_hd__mux2_2
* cell instance sky130_fd_sc_hd__mux2_2_195 r0 *1 0,0
Xsky130_fd_sc_hd__mux2_2_195 cnt_o[7] count_r[4][7] \_0362_ VSS VDD VDD \_0125_
+ sky130_fd_sc_hd__mux2_2
* cell instance sky130_fd_sc_hd__mux2_2_196 r0 *1 0,0
Xsky130_fd_sc_hd__mux2_2_196 cnt_o[19] count_r[1][19] \_0356_ VSS VDD VDD
+ \_0065_ sky130_fd_sc_hd__mux2_2
* cell instance sky130_fd_sc_hd__mux2_2_197 r0 *1 0,0
Xsky130_fd_sc_hd__mux2_2_197 cnt_o[19] count_r[2][19] \_0344_ VSS VDD VDD
+ \_0017_ sky130_fd_sc_hd__mux2_2
* cell instance sky130_fd_sc_hd__mux2_2_198 r0 *1 0,0
Xsky130_fd_sc_hd__mux2_2_198 cnt_o[19] count_r[4][19] \_0362_ VSS VDD VDD
+ \_0113_ sky130_fd_sc_hd__mux2_2
* cell instance sky130_fd_sc_hd__mux2_2_199 r0 *1 0,0
Xsky130_fd_sc_hd__mux2_2_199 cnt_o[19] count_r[3][19] net12 VSS VDD VDD \_0042_
+ sky130_fd_sc_hd__mux2_2
* cell instance sky130_fd_sc_hd__mux2_2_200 r0 *1 0,0
Xsky130_fd_sc_hd__mux2_2_200 cnt_o[6] count_r[3][6] net12 VSS VDD VDD \_0055_
+ sky130_fd_sc_hd__mux2_2
* cell instance sky130_fd_sc_hd__mux2_2_201 r0 *1 0,0
Xsky130_fd_sc_hd__mux2_2_201 cnt_o[23] count_r[4][23] \_0362_ VSS VDD VDD
+ \_0262_ sky130_fd_sc_hd__mux2_2
* cell instance sky130_fd_sc_hd__mux2_2_202 r0 *1 0,0
Xsky130_fd_sc_hd__mux2_2_202 cnt_o[6] count_r[4][6] \_0362_ VSS VDD VDD \_0126_
+ sky130_fd_sc_hd__mux2_2
* cell instance sky130_fd_sc_hd__mux2_2_203 r0 *1 0,0
Xsky130_fd_sc_hd__mux2_2_203 cnt_o[7] count_r[3][7] net12 VSS VDD VDD \_0054_
+ sky130_fd_sc_hd__mux2_2
* cell instance sky130_fd_sc_hd__mux2_2_204 r0 *1 0,0
Xsky130_fd_sc_hd__mux2_2_204 cnt_o[23] count_r[0][23] \_0447_ VSS VDD VDD
+ \_0209_ sky130_fd_sc_hd__mux2_2
* cell instance sky130_fd_sc_hd__mux2_2_205 r0 *1 0,0
Xsky130_fd_sc_hd__mux2_2_205 cnt_o[7] count_r[0][7] \_0447_ VSS VDD VDD \_0265_
+ sky130_fd_sc_hd__mux2_2
* cell instance sky130_fd_sc_hd__mux2_2_206 r0 *1 0,0
Xsky130_fd_sc_hd__mux2_2_206 cnt_o[19] count_r[0][19] \_0447_ VSS VDD VDD
+ \_0252_ sky130_fd_sc_hd__mux2_2
* cell instance sky130_fd_sc_hd__mux2_2_207 r0 *1 0,0
Xsky130_fd_sc_hd__mux2_2_207 cnt_o[6] count_r[1][6] \_0356_ VSS VDD VDD \_0078_
+ sky130_fd_sc_hd__mux2_2
* cell instance sky130_fd_sc_hd__mux2_2_208 r0 *1 0,0
Xsky130_fd_sc_hd__mux2_2_208 cnt_o[6] count_r[0][6] \_0447_ VSS VDD VDD \_0266_
+ sky130_fd_sc_hd__mux2_2
* cell instance sky130_fd_sc_hd__mux2_2_209 r0 *1 0,0
Xsky130_fd_sc_hd__mux2_2_209 cnt_o[3] count_r[1][3] \_0356_ VSS VDD VDD \_0081_
+ sky130_fd_sc_hd__mux2_2
* cell instance sky130_fd_sc_hd__mux2_2_210 r0 *1 0,0
Xsky130_fd_sc_hd__mux2_2_210 cnt_o[3] count_r[3][3] net12 VSS VDD VDD \_0058_
+ sky130_fd_sc_hd__mux2_2
* cell instance sky130_fd_sc_hd__mux2_2_211 r0 *1 0,0
Xsky130_fd_sc_hd__mux2_2_211 cnt_o[23] count_r[1][23] \_0356_ VSS VDD VDD
+ \_0201_ sky130_fd_sc_hd__mux2_2
* cell instance sky130_fd_sc_hd__mux2_2_212 r0 *1 0,0
Xsky130_fd_sc_hd__mux2_2_212 cnt_o[6] count_r[2][6] \_0344_ VSS VDD VDD \_0030_
+ sky130_fd_sc_hd__mux2_2
* cell instance sky130_fd_sc_hd__mux2_2_213 r0 *1 0,0
Xsky130_fd_sc_hd__mux2_2_213 cnt_o[9] count_r[1][9] \_0356_ VSS VDD VDD \_0075_
+ sky130_fd_sc_hd__mux2_2
* cell instance sky130_fd_sc_hd__mux2_2_214 r0 *1 0,0
Xsky130_fd_sc_hd__mux2_2_214 cnt_o[3] count_r[0][3] \_0447_ VSS VDD VDD \_0269_
+ sky130_fd_sc_hd__mux2_2
* cell instance sky130_fd_sc_hd__mux2_2_215 r0 *1 0,0
Xsky130_fd_sc_hd__mux2_2_215 cnt_o[23] count_r[2][23] \_0344_ VSS VDD VDD
+ \_0205_ sky130_fd_sc_hd__mux2_2
* cell instance sky130_fd_sc_hd__mux2_2_216 r0 *1 0,0
Xsky130_fd_sc_hd__mux2_2_216 cnt_o[23] count_r[3][23] net12 VSS VDD VDD \_0203_
+ sky130_fd_sc_hd__mux2_2
* cell instance sky130_fd_sc_hd__mux2_2_217 r0 *1 0,0
Xsky130_fd_sc_hd__mux2_2_217 cnt_o[13] count_r[0][13] \_0447_ VSS VDD VDD
+ \_0258_ sky130_fd_sc_hd__mux2_2
* cell instance sky130_fd_sc_hd__mux2_2_218 r0 *1 0,0
Xsky130_fd_sc_hd__mux2_2_218 cnt_o[3] count_r[2][3] \_0344_ VSS VDD VDD \_0033_
+ sky130_fd_sc_hd__mux2_2
* cell instance sky130_fd_sc_hd__mux2_2_219 r0 *1 0,0
Xsky130_fd_sc_hd__mux2_2_219 cnt_o[3] count_r[4][3] \_0362_ VSS VDD VDD \_0129_
+ sky130_fd_sc_hd__mux2_2
* cell instance sky130_fd_sc_hd__mux2_2_220 r0 *1 0,0
Xsky130_fd_sc_hd__mux2_2_220 cnt_o[11] count_r[3][11] net12 VSS VDD VDD \_0050_
+ sky130_fd_sc_hd__mux2_2
* cell instance sky130_fd_sc_hd__mux2_2_221 r0 *1 0,0
Xsky130_fd_sc_hd__mux2_2_221 cnt_o[5] count_r[3][5] net12 VSS VDD VDD \_0056_
+ sky130_fd_sc_hd__mux2_2
* cell instance sky130_fd_sc_hd__mux2_2_222 r0 *1 0,0
Xsky130_fd_sc_hd__mux2_2_222 cnt_o[8] count_r[3][8] net12 VSS VDD VDD \_0053_
+ sky130_fd_sc_hd__mux2_2
* cell instance sky130_fd_sc_hd__mux2_2_223 r0 *1 0,0
Xsky130_fd_sc_hd__mux2_2_223 cnt_o[9] count_r[3][9] net12 VSS VDD VDD \_0052_
+ sky130_fd_sc_hd__mux2_2
* cell instance sky130_fd_sc_hd__mux2_2_224 r0 *1 0,0
Xsky130_fd_sc_hd__mux2_2_224 cnt_o[9] count_r[2][9] \_0344_ VSS VDD VDD \_0027_
+ sky130_fd_sc_hd__mux2_2
* cell instance sky130_fd_sc_hd__mux2_2_225 r0 *1 0,0
Xsky130_fd_sc_hd__mux2_2_225 cnt_o[13] count_r[1][13] \_0356_ VSS VDD VDD
+ \_0071_ sky130_fd_sc_hd__mux2_2
* cell instance sky130_fd_sc_hd__mux2_2_226 r0 *1 0,0
Xsky130_fd_sc_hd__mux2_2_226 cnt_o[4] count_r[3][4] net12 VSS VDD VDD \_0057_
+ sky130_fd_sc_hd__mux2_2
* cell instance sky130_fd_sc_hd__mux2_2_227 r0 *1 0,0
Xsky130_fd_sc_hd__mux2_2_227 cnt_o[13] count_r[3][13] net12 VSS VDD VDD \_0048_
+ sky130_fd_sc_hd__mux2_2
* cell instance sky130_fd_sc_hd__mux2_2_228 r0 *1 0,0
Xsky130_fd_sc_hd__mux2_2_228 cnt_o[11] count_r[2][11] \_0344_ VSS VDD VDD
+ \_0025_ sky130_fd_sc_hd__mux2_2
* cell instance sky130_fd_sc_hd__mux2_2_229 r0 *1 0,0
Xsky130_fd_sc_hd__mux2_2_229 cnt_o[5] count_r[2][5] \_0344_ VSS VDD VDD \_0031_
+ sky130_fd_sc_hd__mux2_2
* cell instance sky130_fd_sc_hd__mux2_2_230 r0 *1 0,0
Xsky130_fd_sc_hd__mux2_2_230 cnt_o[13] count_r[2][13] \_0344_ VSS VDD VDD
+ \_0023_ sky130_fd_sc_hd__mux2_2
* cell instance sky130_fd_sc_hd__mux2_2_231 r0 *1 0,0
Xsky130_fd_sc_hd__mux2_2_231 cnt_o[4] count_r[2][4] \_0344_ VSS VDD VDD \_0032_
+ sky130_fd_sc_hd__mux2_2
* cell instance sky130_fd_sc_hd__mux2_2_232 r0 *1 0,0
Xsky130_fd_sc_hd__mux2_2_232 cnt_o[8] count_r[2][8] \_0344_ VSS VDD VDD \_0028_
+ sky130_fd_sc_hd__mux2_2
* cell instance sky130_fd_sc_hd__mux2_2_233 r0 *1 0,0
Xsky130_fd_sc_hd__mux2_2_233 cnt_o[13] count_r[4][13] \_0362_ VSS VDD VDD
+ \_0119_ sky130_fd_sc_hd__mux2_2
* cell instance sky130_fd_sc_hd__mux2_2_234 r0 *1 0,0
Xsky130_fd_sc_hd__mux2_2_234 cnt_o[5] count_r[4][5] \_0362_ VSS VDD VDD \_0127_
+ sky130_fd_sc_hd__mux2_2
* cell instance sky130_fd_sc_hd__mux2_2_235 r0 *1 0,0
Xsky130_fd_sc_hd__mux2_2_235 cnt_o[8] count_r[4][8] \_0362_ VSS VDD VDD \_0124_
+ sky130_fd_sc_hd__mux2_2
* cell instance sky130_fd_sc_hd__mux2_2_236 r0 *1 0,0
Xsky130_fd_sc_hd__mux2_2_236 cnt_o[11] count_r[4][11] \_0362_ VSS VDD VDD
+ \_0121_ sky130_fd_sc_hd__mux2_2
* cell instance sky130_fd_sc_hd__mux2_2_237 r0 *1 0,0
Xsky130_fd_sc_hd__mux2_2_237 cnt_o[4] count_r[4][4] \_0362_ VSS VDD VDD \_0128_
+ sky130_fd_sc_hd__mux2_2
* cell instance sky130_fd_sc_hd__mux2_2_238 r0 *1 0,0
Xsky130_fd_sc_hd__mux2_2_238 cnt_o[11] count_r[1][11] \_0356_ VSS VDD VDD
+ \_0073_ sky130_fd_sc_hd__mux2_2
* cell instance sky130_fd_sc_hd__mux2_2_239 r0 *1 0,0
Xsky130_fd_sc_hd__mux2_2_239 cnt_o[9] count_r[4][9] \_0362_ VSS VDD VDD \_0123_
+ sky130_fd_sc_hd__mux2_2
* cell instance sky130_fd_sc_hd__mux2_2_240 r0 *1 0,0
Xsky130_fd_sc_hd__mux2_2_240 cnt_o[11] count_r[0][11] \_0447_ VSS VDD VDD
+ \_0260_ sky130_fd_sc_hd__mux2_2
* cell instance sky130_fd_sc_hd__mux2_2_241 r0 *1 0,0
Xsky130_fd_sc_hd__mux2_2_241 cnt_o[8] count_r[1][8] \_0356_ VSS VDD VDD \_0076_
+ sky130_fd_sc_hd__mux2_2
* cell instance sky130_fd_sc_hd__mux2_2_242 r0 *1 0,0
Xsky130_fd_sc_hd__mux2_2_242 cnt_o[8] count_r[0][8] \_0447_ VSS VDD VDD \_0264_
+ sky130_fd_sc_hd__mux2_2
* cell instance sky130_fd_sc_hd__mux2_2_243 r0 *1 0,0
Xsky130_fd_sc_hd__mux2_2_243 cnt_o[9] count_r[0][9] \_0447_ VSS VDD VDD \_0263_
+ sky130_fd_sc_hd__mux2_2
* cell instance sky130_fd_sc_hd__mux2_2_244 r0 *1 0,0
Xsky130_fd_sc_hd__mux2_2_244 cnt_o[5] count_r[1][5] \_0356_ VSS VDD VDD \_0079_
+ sky130_fd_sc_hd__mux2_2
* cell instance sky130_fd_sc_hd__mux2_2_245 r0 *1 0,0
Xsky130_fd_sc_hd__mux2_2_245 cnt_o[5] count_r[0][5] \_0447_ VSS VDD VDD \_0267_
+ sky130_fd_sc_hd__mux2_2
* cell instance sky130_fd_sc_hd__mux2_2_246 r0 *1 0,0
Xsky130_fd_sc_hd__mux2_2_246 cnt_o[4] count_r[1][4] \_0356_ VSS VDD VDD \_0080_
+ sky130_fd_sc_hd__mux2_2
* cell instance sky130_fd_sc_hd__mux2_2_247 r0 *1 0,0
Xsky130_fd_sc_hd__mux2_2_247 cnt_o[4] count_r[0][4] \_0447_ VSS VDD VDD \_0268_
+ sky130_fd_sc_hd__mux2_2
* cell instance sky130_fd_sc_hd__nand2_1_0 r0 *1 0,0
Xsky130_fd_sc_hd__nand2_1_0 cal_r[0][12] \_0496_ VSS VDD VDD \_0594_
+ sky130_fd_sc_hd__nand2_1
* cell instance sky130_fd_sc_hd__nand2_1_1 r0 *1 0,0
Xsky130_fd_sc_hd__nand2_1_1 cal_r[0][15] \_0496_ VSS VDD VDD \_0566_
+ sky130_fd_sc_hd__nand2_1
* cell instance sky130_fd_sc_hd__nand2_1_2 r0 *1 0,0
Xsky130_fd_sc_hd__nand2_1_2 cal_r[0][19] \_0496_ VSS VDD VDD \_0534_
+ sky130_fd_sc_hd__nand2_1
* cell instance sky130_fd_sc_hd__nand2_1_3 r0 *1 0,0
Xsky130_fd_sc_hd__nand2_1_3 cal_r[0][17] \_0496_ VSS VDD VDD \_0549_
+ sky130_fd_sc_hd__nand2_1
* cell instance sky130_fd_sc_hd__nand2_1_4 r0 *1 0,0
Xsky130_fd_sc_hd__nand2_1_4 cal_r[0][13] \_0496_ VSS VDD VDD \_0586_
+ sky130_fd_sc_hd__nand2_1
* cell instance sky130_fd_sc_hd__nand2_1_5 r0 *1 0,0
Xsky130_fd_sc_hd__nand2_1_5 \_0594_ \_0595_ VSS VDD VDD \_0596_
+ sky130_fd_sc_hd__nand2_1
* cell instance sky130_fd_sc_hd__nand2_1_6 r0 *1 0,0
Xsky130_fd_sc_hd__nand2_1_6 \_0566_ \_0567_ VSS VDD VDD \_0568_
+ sky130_fd_sc_hd__nand2_1
* cell instance sky130_fd_sc_hd__nand2_1_7 r0 *1 0,0
Xsky130_fd_sc_hd__nand2_1_7 \_0534_ \_0537_ VSS VDD VDD \_0538_
+ sky130_fd_sc_hd__nand2_1
* cell instance sky130_fd_sc_hd__nand2_1_8 r0 *1 0,0
Xsky130_fd_sc_hd__nand2_1_8 \_0549_ \_0550_ VSS VDD VDD \_0551_
+ sky130_fd_sc_hd__nand2_1
* cell instance sky130_fd_sc_hd__nand2_1_9 r0 *1 0,0
Xsky130_fd_sc_hd__nand2_1_9 \_0498_ \_0504_ VSS VDD VDD \_0505_
+ sky130_fd_sc_hd__nand2_1
* cell instance sky130_fd_sc_hd__nand2_1_10 r0 *1 0,0
Xsky130_fd_sc_hd__nand2_1_10 cal_r[0][23] \_0496_ VSS VDD VDD \_0321_
+ sky130_fd_sc_hd__nand2_1
* cell instance sky130_fd_sc_hd__nand2_1_11 r0 *1 0,0
Xsky130_fd_sc_hd__nand2_1_11 cal_r[0][22] \_0496_ VSS VDD VDD \_0498_
+ sky130_fd_sc_hd__nand2_1
* cell instance sky130_fd_sc_hd__nand2_1_12 r0 *1 0,0
Xsky130_fd_sc_hd__nand2_1_12 \_0586_ \_0587_ VSS VDD VDD \_0588_
+ sky130_fd_sc_hd__nand2_1
* cell instance sky130_fd_sc_hd__nand2_1_13 r0 *1 0,0
Xsky130_fd_sc_hd__nand2_1_13 \_0321_ \_0322_ VSS VDD VDD \_0323_
+ sky130_fd_sc_hd__nand2_1
* cell instance sky130_fd_sc_hd__nand2_1_14 r0 *1 0,0
Xsky130_fd_sc_hd__nand2_1_14 \_0490_ \_0495_ VSS VDD VDD \_0496_
+ sky130_fd_sc_hd__nand2_1
* cell instance sky130_fd_sc_hd__nand2_1_15 r0 *1 0,0
Xsky130_fd_sc_hd__nand2_1_15 addr[3] \_0490_ VSS VDD VDD \_0491_
+ sky130_fd_sc_hd__nand2_1
* cell instance sky130_fd_sc_hd__nand2_1_16 r0 *1 0,0
Xsky130_fd_sc_hd__nand2_1_16 cal_r[3][0] net15 VSS VDD VDD \_0686_
+ sky130_fd_sc_hd__nand2_1
* cell instance sky130_fd_sc_hd__nand2_1_17 r0 *1 0,0
Xsky130_fd_sc_hd__nand2_1_17 cal_r[0][10] \_0496_ VSS VDD VDD \_0606_
+ sky130_fd_sc_hd__nand2_1
* cell instance sky130_fd_sc_hd__nand2_1_18 r0 *1 0,0
Xsky130_fd_sc_hd__nand2_1_18 cal_r[0][0] \_0496_ VSS VDD VDD \_0685_
+ sky130_fd_sc_hd__nand2_1
* cell instance sky130_fd_sc_hd__nand2_1_19 r0 *1 0,0
Xsky130_fd_sc_hd__nand2_1_19 \_0680_ \_0684_ VSS VDD VDD rdata[1]
+ sky130_fd_sc_hd__nand2_1
* cell instance sky130_fd_sc_hd__nand2_1_20 r0 *1 0,0
Xsky130_fd_sc_hd__nand2_1_20 \_0606_ \_0607_ VSS VDD VDD \_0608_
+ sky130_fd_sc_hd__nand2_1
* cell instance sky130_fd_sc_hd__nand2_1_21 r0 *1 0,0
Xsky130_fd_sc_hd__nand2_1_21 cal_r[0][20] \_0496_ VSS VDD VDD \_0524_
+ sky130_fd_sc_hd__nand2_1
* cell instance sky130_fd_sc_hd__nand2_1_22 r0 *1 0,0
Xsky130_fd_sc_hd__nand2_1_22 \_0524_ \_0525_ VSS VDD VDD \_0526_
+ sky130_fd_sc_hd__nand2_1
* cell instance sky130_fd_sc_hd__nand2_1_23 r0 *1 0,0
Xsky130_fd_sc_hd__nand2_1_23 \_0540_ \_0541_ VSS VDD VDD \_0542_
+ sky130_fd_sc_hd__nand2_1
* cell instance sky130_fd_sc_hd__nand2_1_24 r0 *1 0,0
Xsky130_fd_sc_hd__nand2_1_24 cal_r[0][2] \_0496_ VSS VDD VDD \_0672_
+ sky130_fd_sc_hd__nand2_1
* cell instance sky130_fd_sc_hd__nand2_1_25 r0 *1 0,0
Xsky130_fd_sc_hd__nand2_1_25 cal_r[0][18] \_0496_ VSS VDD VDD \_0540_
+ sky130_fd_sc_hd__nand2_1
* cell instance sky130_fd_sc_hd__nand2_1_26 r0 *1 0,0
Xsky130_fd_sc_hd__nand2_1_26 cal_r[0][14] \_0496_ VSS VDD VDD \_0574_
+ sky130_fd_sc_hd__nand2_1
* cell instance sky130_fd_sc_hd__nand2_1_27 r0 *1 0,0
Xsky130_fd_sc_hd__nand2_1_27 \_0574_ \_0575_ VSS VDD VDD \_0576_
+ sky130_fd_sc_hd__nand2_1
* cell instance sky130_fd_sc_hd__nand2_1_28 r0 *1 0,0
Xsky130_fd_sc_hd__nand2_1_28 cal_r[3][2] net15 VSS VDD VDD \_0673_
+ sky130_fd_sc_hd__nand2_1
* cell instance sky130_fd_sc_hd__nand2_1_29 r0 *1 0,0
Xsky130_fd_sc_hd__nand2_1_29 cal_r[0][21] \_0496_ VSS VDD VDD \_0514_
+ sky130_fd_sc_hd__nand2_1
* cell instance sky130_fd_sc_hd__nand2_1_30 r0 *1 0,0
Xsky130_fd_sc_hd__nand2_1_30 \_0671_ \_0676_ VSS VDD VDD rdata[2]
+ sky130_fd_sc_hd__nand2_1
* cell instance sky130_fd_sc_hd__nand2_1_31 r0 *1 0,0
Xsky130_fd_sc_hd__nand2_1_31 \_0514_ \_0516_ VSS VDD VDD \_0517_
+ sky130_fd_sc_hd__nand2_1
* cell instance sky130_fd_sc_hd__nand2_1_32 r0 *1 0,0
Xsky130_fd_sc_hd__nand2_1_32 cal_r[0][4] \_0496_ VSS VDD VDD \_0653_
+ sky130_fd_sc_hd__nand2_1
* cell instance sky130_fd_sc_hd__nand2_1_33 r0 *1 0,0
Xsky130_fd_sc_hd__nand2_1_33 cal_r[0][11] \_0496_ VSS VDD VDD \_0602_
+ sky130_fd_sc_hd__nand2_1
* cell instance sky130_fd_sc_hd__nand2_1_34 r0 *1 0,0
Xsky130_fd_sc_hd__nand2_1_34 \_0653_ \_0654_ VSS VDD VDD \_0655_
+ sky130_fd_sc_hd__nand2_1
* cell instance sky130_fd_sc_hd__nand2_1_35 r0 *1 0,0
Xsky130_fd_sc_hd__nand2_1_35 \_0561_ \_0562_ VSS VDD VDD \_0563_
+ sky130_fd_sc_hd__nand2_1
* cell instance sky130_fd_sc_hd__nand2_1_36 r0 *1 0,0
Xsky130_fd_sc_hd__nand2_1_36 \_0602_ \_0603_ VSS VDD VDD \_0604_
+ sky130_fd_sc_hd__nand2_1
* cell instance sky130_fd_sc_hd__nand2_1_37 r0 *1 0,0
Xsky130_fd_sc_hd__nand2_1_37 \_0614_ \_0615_ VSS VDD VDD \_0616_
+ sky130_fd_sc_hd__nand2_1
* cell instance sky130_fd_sc_hd__nand2_1_38 r0 *1 0,0
Xsky130_fd_sc_hd__nand2_1_38 cal_r[0][16] \_0496_ VSS VDD VDD \_0561_
+ sky130_fd_sc_hd__nand2_1
* cell instance sky130_fd_sc_hd__nand2_1_39 r0 *1 0,0
Xsky130_fd_sc_hd__nand2_1_39 cal_r[0][9] \_0496_ VSS VDD VDD \_0614_
+ sky130_fd_sc_hd__nand2_1
* cell instance sky130_fd_sc_hd__nand2_1_40 r0 *1 0,0
Xsky130_fd_sc_hd__nand2_1_40 cal_r[2][5] net19 VSS VDD VDD \_0645_
+ sky130_fd_sc_hd__nand2_1
* cell instance sky130_fd_sc_hd__nand2_1_41 r0 *1 0,0
Xsky130_fd_sc_hd__nand2_1_41 cal_r[0][5] \_0496_ VSS VDD VDD \_0644_
+ sky130_fd_sc_hd__nand2_1
* cell instance sky130_fd_sc_hd__nand2_1_42 r0 *1 0,0
Xsky130_fd_sc_hd__nand2_1_42 sel_q[2] \_0348_ VSS VDD VDD \_0444_
+ sky130_fd_sc_hd__nand2_1
* cell instance sky130_fd_sc_hd__nand2_1_43 r0 *1 0,0
Xsky130_fd_sc_hd__nand2_1_43 \_0443_ \_0444_ VSS VDD VDD \_0204_
+ sky130_fd_sc_hd__nand2_1
* cell instance sky130_fd_sc_hd__nand2_1_44 r0 *1 0,0
Xsky130_fd_sc_hd__nand2_1_44 \_0333_ \_0343_ VSS VDD VDD \_0356_
+ sky130_fd_sc_hd__nand2_1
* cell instance sky130_fd_sc_hd__nand2_1_45 r0 *1 0,0
Xsky130_fd_sc_hd__nand2_1_45 wdata[3] net13 VSS VDD VDD \_0443_
+ sky130_fd_sc_hd__nand2_1
* cell instance sky130_fd_sc_hd__nand2_1_46 r0 *1 0,0
Xsky130_fd_sc_hd__nand2_1_46 cal_r[0][8] \_0496_ VSS VDD VDD \_0622_
+ sky130_fd_sc_hd__nand2_1
* cell instance sky130_fd_sc_hd__nand2_1_47 r0 *1 0,0
Xsky130_fd_sc_hd__nand2_1_47 \_0332_ \_0343_ VSS VDD VDD \_0447_
+ sky130_fd_sc_hd__nand2_1
* cell instance sky130_fd_sc_hd__nand2_1_48 r0 *1 0,0
Xsky130_fd_sc_hd__nand2_1_48 \_0508_ \_0511_ VSS VDD VDD \_0512_
+ sky130_fd_sc_hd__nand2_1
* cell instance sky130_fd_sc_hd__nand2_1_49 r0 *1 0,0
Xsky130_fd_sc_hd__nand2_1_49 \_0622_ \_0623_ VSS VDD VDD \_0624_
+ sky130_fd_sc_hd__nand2_1
* cell instance sky130_fd_sc_hd__nand2_1_50 r0 *1 0,0
Xsky130_fd_sc_hd__nand2_1_50 count_r[0][21] net17 VSS VDD VDD \_0508_
+ sky130_fd_sc_hd__nand2_1
* cell instance sky130_fd_sc_hd__nand2_1_51 r0 *1 0,0
Xsky130_fd_sc_hd__nand2_1_51 count_r[0][16] net17 VSS VDD VDD \_0557_
+ sky130_fd_sc_hd__nand2_1
* cell instance sky130_fd_sc_hd__nand2_1_52 r0 *1 0,0
Xsky130_fd_sc_hd__nand2_1_52 \_0519_ \_0521_ VSS VDD VDD \_0522_
+ sky130_fd_sc_hd__nand2_1
* cell instance sky130_fd_sc_hd__nand2_1_53 r0 *1 0,0
Xsky130_fd_sc_hd__nand2_1_53 \_0335_ \_0343_ VSS VDD VDD \_0362_
+ sky130_fd_sc_hd__nand2_1
* cell instance sky130_fd_sc_hd__nand2_1_54 r0 *1 0,0
Xsky130_fd_sc_hd__nand2_1_54 \_0557_ \_0558_ VSS VDD VDD \_0559_
+ sky130_fd_sc_hd__nand2_1
* cell instance sky130_fd_sc_hd__nand2_1_55 r0 *1 0,0
Xsky130_fd_sc_hd__nand2_1_55 count_r[0][20] net17 VSS VDD VDD \_0519_
+ sky130_fd_sc_hd__nand2_1
* cell instance sky130_fd_sc_hd__nand2_1_56 r0 *1 0,0
Xsky130_fd_sc_hd__nand2_1_56 count_r[0][17] net17 VSS VDD VDD \_0553_
+ sky130_fd_sc_hd__nand2_1
* cell instance sky130_fd_sc_hd__nand2_1_57 r0 *1 0,0
Xsky130_fd_sc_hd__nand2_1_57 wdata[7] net13 VSS VDD VDD \_0458_
+ sky130_fd_sc_hd__nand2_1
* cell instance sky130_fd_sc_hd__nand2_1_58 r0 *1 0,0
Xsky130_fd_sc_hd__nand2_1_58 \_0553_ \_0554_ VSS VDD VDD \_0555_
+ sky130_fd_sc_hd__nand2_1
* cell instance sky130_fd_sc_hd__nand2_1_59 r0 *1 0,0
Xsky130_fd_sc_hd__nand2_1_59 \_0464_ \_0465_ VSS VDD VDD \_0281_
+ sky130_fd_sc_hd__nand2_1
* cell instance sky130_fd_sc_hd__nand2_1_60 r0 *1 0,0
Xsky130_fd_sc_hd__nand2_1_60 wdata[4] net13 VSS VDD VDD \_0464_
+ sky130_fd_sc_hd__nand2_1
* cell instance sky130_fd_sc_hd__nand2_1_61 r0 *1 0,0
Xsky130_fd_sc_hd__nand2_1_61 \_0458_ \_0459_ VSS VDD VDD \_0278_
+ sky130_fd_sc_hd__nand2_1
* cell instance sky130_fd_sc_hd__nand2_1_62 r0 *1 0,0
Xsky130_fd_sc_hd__nand2_1_62 \_0468_ \_0467_ VSS VDD VDD \_0482_
+ sky130_fd_sc_hd__nand2_1
* cell instance sky130_fd_sc_hd__nand2_1_63 r0 *1 0,0
Xsky130_fd_sc_hd__nand2_1_63 k_q[0] \_0348_ VSS VDD VDD \_0465_
+ sky130_fd_sc_hd__nand2_1
* cell instance sky130_fd_sc_hd__nand2_1_64 r0 *1 0,0
Xsky130_fd_sc_hd__nand2_1_64 \_0468_ \_0466_ VSS VDD VDD \_0475_
+ sky130_fd_sc_hd__nand2_1
* cell instance sky130_fd_sc_hd__nand2_1_65 r0 *1 0,0
Xsky130_fd_sc_hd__nand2_1_65 k_q[3] \_0348_ VSS VDD VDD \_0459_
+ sky130_fd_sc_hd__nand2_1
* cell instance sky130_fd_sc_hd__nand2_1_66 r0 *1 0,0
Xsky130_fd_sc_hd__nand2_1_66 count_r[0][18] net17 VSS VDD VDD \_0544_
+ sky130_fd_sc_hd__nand2_1
* cell instance sky130_fd_sc_hd__nand2_1_67 r0 *1 0,0
Xsky130_fd_sc_hd__nand2_1_67 \_0544_ \_0545_ VSS VDD VDD \_0546_
+ sky130_fd_sc_hd__nand2_1
* cell instance sky130_fd_sc_hd__nand2_1_68 r0 *1 0,0
Xsky130_fd_sc_hd__nand2_1_68 wdata[6] net13 VSS VDD VDD \_0460_
+ sky130_fd_sc_hd__nand2_1
* cell instance sky130_fd_sc_hd__nand2_1_69 r0 *1 0,0
Xsky130_fd_sc_hd__nand2_1_69 \_0460_ \_0461_ VSS VDD VDD \_0279_
+ sky130_fd_sc_hd__nand2_1
* cell instance sky130_fd_sc_hd__nand2_1_70 r0 *1 0,0
Xsky130_fd_sc_hd__nand2_1_70 wdata[5] net13 VSS VDD VDD \_0462_
+ sky130_fd_sc_hd__nand2_1
* cell instance sky130_fd_sc_hd__nand2_1_71 r0 *1 0,0
Xsky130_fd_sc_hd__nand2_1_71 gate_cnt[26] gate_cnt[27] VSS VDD VDD \_0373_
+ sky130_fd_sc_hd__nand2_1
* cell instance sky130_fd_sc_hd__nand2_1_72 r0 *1 0,0
Xsky130_fd_sc_hd__nand2_1_72 k_q[2] \_0348_ VSS VDD VDD \_0461_
+ sky130_fd_sc_hd__nand2_1
* cell instance sky130_fd_sc_hd__nand2_1_73 r0 *1 0,0
Xsky130_fd_sc_hd__nand2_1_73 \_0462_ \_0463_ VSS VDD VDD \_0280_
+ sky130_fd_sc_hd__nand2_1
* cell instance sky130_fd_sc_hd__nand2_1_74 r0 *1 0,0
Xsky130_fd_sc_hd__nand2_1_74 k_q[1] \_0348_ VSS VDD VDD \_0463_
+ sky130_fd_sc_hd__nand2_1
* cell instance sky130_fd_sc_hd__nand2_1_75 r0 *1 0,0
Xsky130_fd_sc_hd__nand2_1_75 \_0590_ \_0591_ VSS VDD VDD \_0592_
+ sky130_fd_sc_hd__nand2_1
* cell instance sky130_fd_sc_hd__nand2_1_76 r0 *1 0,0
Xsky130_fd_sc_hd__nand2_1_76 count_r[0][12] \_0476_ VSS VDD VDD \_0590_
+ sky130_fd_sc_hd__nand2_1
* cell instance sky130_fd_sc_hd__nand2_1_77 r0 *1 0,0
Xsky130_fd_sc_hd__nand2_1_77 gate_cnt[25] \_0723_ VSS VDD VDD \_0724_
+ sky130_fd_sc_hd__nand2_1
* cell instance sky130_fd_sc_hd__nand2_1_78 r0 *1 0,0
Xsky130_fd_sc_hd__nand2_1_78 \_0478_ \_0487_ VSS VDD VDD \_0488_
+ sky130_fd_sc_hd__nand2_1
* cell instance sky130_fd_sc_hd__nand2_1_79 r0 *1 0,0
Xsky130_fd_sc_hd__nand2_1_79 \_0578_ \_0579_ VSS VDD VDD \_0580_
+ sky130_fd_sc_hd__nand2_1
* cell instance sky130_fd_sc_hd__nand2_1_80 r0 *1 0,0
Xsky130_fd_sc_hd__nand2_1_80 count_r[0][14] net17 VSS VDD VDD \_0578_
+ sky130_fd_sc_hd__nand2_1
* cell instance sky130_fd_sc_hd__nand2_1_81 r0 *1 0,0
Xsky130_fd_sc_hd__nand2_1_81 count_r[0][22] net17 VSS VDD VDD \_0478_
+ sky130_fd_sc_hd__nand2_1
* cell instance sky130_fd_sc_hd__nand2_1_82 r0 *1 0,0
Xsky130_fd_sc_hd__nand2_1_82 \_0610_ \_0611_ VSS VDD VDD \_0612_
+ sky130_fd_sc_hd__nand2_1
* cell instance sky130_fd_sc_hd__nand2_1_83 r0 *1 0,0
Xsky130_fd_sc_hd__nand2_1_83 count_r[0][10] \_0476_ VSS VDD VDD \_0610_
+ sky130_fd_sc_hd__nand2_1
* cell instance sky130_fd_sc_hd__nand2_1_84 r0 *1 0,0
Xsky130_fd_sc_hd__nand2_1_84 k_q[4] \_0698_ VSS VDD VDD \_0699_
+ sky130_fd_sc_hd__nand2_1
* cell instance sky130_fd_sc_hd__nand2_1_85 r0 *1 0,0
Xsky130_fd_sc_hd__nand2_1_85 gate_cnt[30] \_0381_ VSS VDD VDD \_0454_
+ sky130_fd_sc_hd__nand2_1
* cell instance sky130_fd_sc_hd__nand2_1_86 r0 *1 0,0
Xsky130_fd_sc_hd__nand2_1_86 \_0570_ \_0571_ VSS VDD VDD \_0572_
+ sky130_fd_sc_hd__nand2_1
* cell instance sky130_fd_sc_hd__nand2_1_87 r0 *1 0,0
Xsky130_fd_sc_hd__nand2_1_87 gate_cnt[24] \_0300_ VSS VDD VDD \_0311_
+ sky130_fd_sc_hd__nand2_1
* cell instance sky130_fd_sc_hd__nand2_1_88 r0 *1 0,0
Xsky130_fd_sc_hd__nand2_1_88 k_q[3] k_q[4] VSS VDD VDD \_0733_
+ sky130_fd_sc_hd__nand2_1
* cell instance sky130_fd_sc_hd__nand2_1_89 r0 *1 0,0
Xsky130_fd_sc_hd__nand2_1_89 \_0701_ \_0380_ VSS VDD VDD \_0384_
+ sky130_fd_sc_hd__nand2_1
* cell instance sky130_fd_sc_hd__nand2_1_90 r0 *1 0,0
Xsky130_fd_sc_hd__nand2_1_90 count_r[0][15] net17 VSS VDD VDD \_0570_
+ sky130_fd_sc_hd__nand2_1
* cell instance sky130_fd_sc_hd__nand2_1_91 r0 *1 0,0
Xsky130_fd_sc_hd__nand2_1_91 u_cnt/_095_ u_cnt/_100_ VSS VDD VDD u_cnt/_004_
+ sky130_fd_sc_hd__nand2_1
* cell instance sky130_fd_sc_hd__nand2_1_92 r0 *1 0,0
Xsky130_fd_sc_hd__nand2_1_92 u_cnt/running u_cnt/_083_ VSS VDD VDD u_cnt/_041_
+ sky130_fd_sc_hd__nand2_1
* cell instance sky130_fd_sc_hd__nand2_1_93 r0 *1 0,0
Xsky130_fd_sc_hd__nand2_1_93 \_0732_ \_0734_ VSS VDD VDD \_0735_
+ sky130_fd_sc_hd__nand2_1
* cell instance sky130_fd_sc_hd__nand2_1_94 r0 *1 0,0
Xsky130_fd_sc_hd__nand2_1_94 cnt_o[17] u_cnt/_078_ VSS VDD VDD u_cnt/_030_
+ sky130_fd_sc_hd__nand2_1
* cell instance sky130_fd_sc_hd__nand2_1_95 r0 *1 0,0
Xsky130_fd_sc_hd__nand2_1_95 gate_cnt[7] \_0728_ VSS VDD VDD \_0732_
+ sky130_fd_sc_hd__nand2_1
* cell instance sky130_fd_sc_hd__nand2_1_96 r0 *1 0,0
Xsky130_fd_sc_hd__nand2_1_96 k_q[2] k_q[1] VSS VDD VDD \_0730_
+ sky130_fd_sc_hd__nand2_1
* cell instance sky130_fd_sc_hd__nand2_1_97 r0 *1 0,0
Xsky130_fd_sc_hd__nand2_1_97 \_0348_ \_0380_ VSS VDD VDD \_0386_
+ sky130_fd_sc_hd__nand2_1
* cell instance sky130_fd_sc_hd__nand2_1_98 r0 *1 0,0
Xsky130_fd_sc_hd__nand2_1_98 \_0529_ \_0530_ VSS VDD VDD \_0531_
+ sky130_fd_sc_hd__nand2_1
* cell instance sky130_fd_sc_hd__nand2_1_99 r0 *1 0,0
Xsky130_fd_sc_hd__nand2_1_99 cnt_o[6] u_cnt/_059_ VSS VDD VDD u_cnt/_060_
+ sky130_fd_sc_hd__nand2_1
* cell instance sky130_fd_sc_hd__nand2_1_100 r0 *1 0,0
Xsky130_fd_sc_hd__nand2_1_100 u_cnt/_072_ u_cnt/running VSS VDD VDD u_cnt/_062_
+ sky130_fd_sc_hd__nand2_1
* cell instance sky130_fd_sc_hd__nand2_1_101 r0 *1 0,0
Xsky130_fd_sc_hd__nand2_1_101 gate_cnt[7] gate_cnt[8] VSS VDD VDD \_0372_
+ sky130_fd_sc_hd__nand2_1
* cell instance sky130_fd_sc_hd__nand2_1_102 r0 *1 0,0
Xsky130_fd_sc_hd__nand2_1_102 count_r[0][19] net17 VSS VDD VDD \_0529_
+ sky130_fd_sc_hd__nand2_1
* cell instance sky130_fd_sc_hd__nand2_1_103 r0 *1 0,0
Xsky130_fd_sc_hd__nand2_1_103 \_0325_ \_0326_ VSS VDD VDD \_0327_
+ sky130_fd_sc_hd__nand2_1
* cell instance sky130_fd_sc_hd__nand2_1_104 r0 *1 0,0
Xsky130_fd_sc_hd__nand2_1_104 cnt_o[8] u_cnt/_075_ VSS VDD VDD u_cnt/_046_
+ sky130_fd_sc_hd__nand2_1
* cell instance sky130_fd_sc_hd__nand2_1_105 r0 *1 0,0
Xsky130_fd_sc_hd__nand2_1_105 count_r[0][23] net17 VSS VDD VDD \_0325_
+ sky130_fd_sc_hd__nand2_1
* cell instance sky130_fd_sc_hd__nand2_1_106 r0 *1 0,0
Xsky130_fd_sc_hd__nand2_1_106 gate_cnt[9] gate_cnt[14] VSS VDD VDD \_0369_
+ sky130_fd_sc_hd__nand2_1
* cell instance sky130_fd_sc_hd__nand2_1_107 r0 *1 0,0
Xsky130_fd_sc_hd__nand2_1_107 count_r[0][13] net17 VSS VDD VDD \_0582_
+ sky130_fd_sc_hd__nand2_1
* cell instance sky130_fd_sc_hd__nand2_1_108 r0 *1 0,0
Xsky130_fd_sc_hd__nand2_1_108 \_0582_ \_0583_ VSS VDD VDD \_0584_
+ sky130_fd_sc_hd__nand2_1
* cell instance sky130_fd_sc_hd__nand2_1_109 r0 *1 0,0
Xsky130_fd_sc_hd__nand2_1_109 \_0618_ \_0619_ VSS VDD VDD \_0620_
+ sky130_fd_sc_hd__nand2_1
* cell instance sky130_fd_sc_hd__nand2_1_110 r0 *1 0,0
Xsky130_fd_sc_hd__nand2_1_110 \_0598_ \_0599_ VSS VDD VDD \_0600_
+ sky130_fd_sc_hd__nand2_1
* cell instance sky130_fd_sc_hd__nand2_1_111 r0 *1 0,0
Xsky130_fd_sc_hd__nand2_1_111 count_r[0][9] net17 VSS VDD VDD \_0618_
+ sky130_fd_sc_hd__nand2_1
* cell instance sky130_fd_sc_hd__nand2_1_112 r0 *1 0,0
Xsky130_fd_sc_hd__nand2_1_112 count_r[0][11] net17 VSS VDD VDD \_0598_
+ sky130_fd_sc_hd__nand2_1
* cell instance sky130_fd_sc_hd__nand2_2_0 r0 *1 0,0
Xsky130_fd_sc_hd__nand2_2_0 we \_0626_ VSS VDD VDD \_0313_
+ sky130_fd_sc_hd__nand2_2
* cell instance sky130_fd_sc_hd__nand2b_1_0 r0 *1 0,0
Xsky130_fd_sc_hd__nand2b_1_0 k_q[4] \_0762_ VSS VDD VDD \_0763_
+ sky130_fd_sc_hd__nand2b_1
* cell instance sky130_fd_sc_hd__nand2b_1_1 r0 *1 0,0
Xsky130_fd_sc_hd__nand2b_1_1 cnt_o[18] u_cnt/running VSS VDD VDD u_cnt/_032_
+ sky130_fd_sc_hd__nand2b_1
* cell instance sky130_fd_sc_hd__nand2b_1_2 r0 *1 0,0
Xsky130_fd_sc_hd__nand2b_1_2 u_cnt/running u_cnt/gate_s2 VSS VDD VDD
+ u_cnt/_095_ sky130_fd_sc_hd__nand2b_1
* cell instance sky130_fd_sc_hd__nand2b_1_3 r0 *1 0,0
Xsky130_fd_sc_hd__nand2b_1_3 cnt_o[9] u_cnt/running VSS VDD VDD u_cnt/_055_
+ sky130_fd_sc_hd__nand2b_1
* cell instance sky130_fd_sc_hd__nand3_1_0 r0 *1 0,0
Xsky130_fd_sc_hd__nand3_1_0 \_0685_ \_0686_ \_0687_ VSS VDD VDD \_0688_
+ sky130_fd_sc_hd__nand3_1
* cell instance sky130_fd_sc_hd__nand3_1_1 r0 *1 0,0
Xsky130_fd_sc_hd__nand3_1_1 we net22 \_0648_ VSS VDD VDD \_0450_
+ sky130_fd_sc_hd__nand3_1
* cell instance sky130_fd_sc_hd__nand3_1_2 r0 *1 0,0
Xsky130_fd_sc_hd__nand3_1_2 we net15 \_0648_ VSS VDD VDD \_0365_
+ sky130_fd_sc_hd__nand3_1
* cell instance sky130_fd_sc_hd__nand3_1_3 r0 *1 0,0
Xsky130_fd_sc_hd__nand3_1_3 we \_0648_ net20 VSS VDD VDD \_0440_
+ sky130_fd_sc_hd__nand3_1
* cell instance sky130_fd_sc_hd__nand3_1_4 r0 *1 0,0
Xsky130_fd_sc_hd__nand3_1_4 we \_0648_ \_0338_ VSS VDD VDD \_0339_
+ sky130_fd_sc_hd__nand3_1
* cell instance sky130_fd_sc_hd__nand3_1_5 r0 *1 0,0
Xsky130_fd_sc_hd__nand3_1_5 we \_0648_ net19 VSS VDD VDD \_0359_
+ sky130_fd_sc_hd__nand3_1
* cell instance sky130_fd_sc_hd__nand3_1_6 r0 *1 0,0
Xsky130_fd_sc_hd__nand3_1_6 \_0644_ \_0645_ \_0646_ VSS VDD VDD \_0647_
+ sky130_fd_sc_hd__nand3_1
* cell instance sky130_fd_sc_hd__nand3_1_7 r0 *1 0,0
Xsky130_fd_sc_hd__nand3_1_7 \_0331_ \_0334_ \_0337_ VSS VDD VDD osc_sel_clk
+ sky130_fd_sc_hd__nand3_1
* cell instance sky130_fd_sc_hd__nand3_1_8 r0 *1 0,0
Xsky130_fd_sc_hd__nand3_1_8 sel_q[1] osc[2] \_0330_ VSS VDD VDD \_0331_
+ sky130_fd_sc_hd__nand3_1
* cell instance sky130_fd_sc_hd__nand3_1_9 r0 *1 0,0
Xsky130_fd_sc_hd__nand3_1_9 sel_q[1] \_0330_ \_0343_ VSS VDD VDD \_0344_
+ sky130_fd_sc_hd__nand3_1
* cell instance sky130_fd_sc_hd__nand3_1_10 r0 *1 0,0
Xsky130_fd_sc_hd__nand3_1_10 k_q[3] k_q[2] k_q[4] VSS VDD VDD \_0717_
+ sky130_fd_sc_hd__nand3_1
* cell instance sky130_fd_sc_hd__nand3_1_11 r0 *1 0,0
Xsky130_fd_sc_hd__nand3_1_11 gate_cnt[24] gate_cnt[25] gate_en VSS VDD VDD
+ \_0378_ sky130_fd_sc_hd__nand3_1
* cell instance sky130_fd_sc_hd__nand3_1_12 r0 *1 0,0
Xsky130_fd_sc_hd__nand3_1_12 k_q[3] k_q[4] \_0705_ VSS VDD VDD \_0706_
+ sky130_fd_sc_hd__nand3_1
* cell instance sky130_fd_sc_hd__nand3_1_13 r0 *1 0,0
Xsky130_fd_sc_hd__nand3_1_13 \_0308_ \_0310_ \_0311_ VSS VDD VDD \_0312_
+ sky130_fd_sc_hd__nand3_1
* cell instance sky130_fd_sc_hd__nand3_1_14 r0 *1 0,0
Xsky130_fd_sc_hd__nand3_1_14 gate_cnt[0] \_0741_ \_0293_ VSS VDD VDD \_0294_
+ sky130_fd_sc_hd__nand3_1
* cell instance sky130_fd_sc_hd__nand3_1_15 r0 *1 0,0
Xsky130_fd_sc_hd__nand3_1_15 k_q[3] k_q[4] \_0745_ VSS VDD VDD \_0300_
+ sky130_fd_sc_hd__nand3_1
* cell instance sky130_fd_sc_hd__nand3_1_16 r0 *1 0,0
Xsky130_fd_sc_hd__nand3_1_16 cnt_o[3] cnt_o[4] cnt_o[5] VSS VDD VDD u_cnt/_074_
+ sky130_fd_sc_hd__nand3_1
* cell instance sky130_fd_sc_hd__nand3_2_0 r0 *1 0,0
Xsky130_fd_sc_hd__nand3_2_0 cnt_o[1] cnt_o[0] cnt_o[2] VSS VDD VDD u_cnt/_073_
+ sky130_fd_sc_hd__nand3_2
* cell instance sky130_fd_sc_hd__nand4_1_0 r0 *1 0,0
Xsky130_fd_sc_hd__nand4_1_0 gate_cnt[18] gate_cnt[19] gate_cnt[20] gate_cnt[21]
+ VSS VDD VDD \_0377_ sky130_fd_sc_hd__nand4_1
* cell instance sky130_fd_sc_hd__nand4_1_1 r0 *1 0,0
Xsky130_fd_sc_hd__nand4_1_1 gate_cnt[16] gate_cnt[17] gate_cnt[22] gate_cnt[23]
+ VSS VDD VDD \_0375_ sky130_fd_sc_hd__nand4_1
* cell instance sky130_fd_sc_hd__nand4_1_2 r0 *1 0,0
Xsky130_fd_sc_hd__nand4_1_2 \_0696_ \_0700_ \_0707_ \_0709_ VSS VDD VDD \_0710_
+ sky130_fd_sc_hd__nand4_1
* cell instance sky130_fd_sc_hd__nand4_1_3 r0 *1 0,0
Xsky130_fd_sc_hd__nand4_1_3 cnt_o[20] u_cnt/gate_s2 u_cnt/_079_ u_cnt/_082_ VSS
+ VDD VDD u_cnt/_103_ sky130_fd_sc_hd__nand4_1
* cell instance sky130_fd_sc_hd__nand4_1_4 r0 *1 0,0
Xsky130_fd_sc_hd__nand4_1_4 gate_cnt[3] gate_cnt[5] gate_cnt[6] gate_cnt[15]
+ VSS VDD VDD \_0376_ sky130_fd_sc_hd__nand4_1
* cell instance sky130_fd_sc_hd__nand4_1_5 r0 *1 0,0
Xsky130_fd_sc_hd__nand4_1_5 gate_cnt[28] \_0370_ \_0374_ \_0379_ VSS VDD VDD
+ \_0380_ sky130_fd_sc_hd__nand4_1
* cell instance sky130_fd_sc_hd__nand4_1_6 r0 *1 0,0
Xsky130_fd_sc_hd__nand4_1_6 gate_cnt[4] gate_cnt[2] gate_cnt[1] gate_cnt[0] VSS
+ VDD VDD \_0371_ sky130_fd_sc_hd__nand4_1
* cell instance sky130_fd_sc_hd__nand4_1_7 r0 *1 0,0
Xsky130_fd_sc_hd__nand4_1_7 cnt_o[13] cnt_o[14] cnt_o[15] cnt_o[16] VSS VDD VDD
+ u_cnt/_077_ sky130_fd_sc_hd__nand4_1
* cell instance sky130_fd_sc_hd__nand4_1_8 r0 *1 0,0
Xsky130_fd_sc_hd__nand4_1_8 gate_cnt[10] gate_cnt[11] gate_cnt[12] gate_cnt[13]
+ VSS VDD VDD \_0368_ sky130_fd_sc_hd__nand4_1
* cell instance sky130_fd_sc_hd__nand4_2_0 r0 *1 0,0
Xsky130_fd_sc_hd__nand4_2_0 cnt_o[8] cnt_o[9] cnt_o[10] u_cnt/_075_ VSS VDD VDD
+ u_cnt/_076_ sky130_fd_sc_hd__nand4_2
* cell instance sky130_fd_sc_hd__nand4b_1_0 r0 *1 0,0
Xsky130_fd_sc_hd__nand4b_1_0 sel_q[2] sel_q[1] \_0343_ sel_q[0] VSS VDD VDD
+ \_0353_ sky130_fd_sc_hd__nand4b_1
* cell instance sky130_fd_sc_hd__nand4bb_1_0 r0 *1 0,0
Xsky130_fd_sc_hd__nand4bb_1_0 busy_r \_0313_ \_0314_ wdata[0] VSS VDD VDD
+ \_0348_ sky130_fd_sc_hd__nand4bb_1
* cell instance sky130_fd_sc_hd__nand4bb_1_1 r0 *1 0,0
Xsky130_fd_sc_hd__nand4bb_1_1 k_q[2] k_q[0] k_q[1] k_q[3] VSS VDD VDD \_0723_
+ sky130_fd_sc_hd__nand4bb_1
* cell instance sky130_fd_sc_hd__nor2_1_0 r0 *1 0,0
Xsky130_fd_sc_hd__nor2_1_0 wdata[1] \_0348_ VSS VDD VDD \_0352_
+ sky130_fd_sc_hd__nor2_1
* cell instance sky130_fd_sc_hd__nor2_1_1 r0 *1 0,0
Xsky130_fd_sc_hd__nor2_1_1 \_0351_ \_0352_ VSS VDD VDD \_0038_
+ sky130_fd_sc_hd__nor2_1
* cell instance sky130_fd_sc_hd__nor2_1_2 r0 *1 0,0
Xsky130_fd_sc_hd__nor2_1_2 wdata[2] \_0348_ VSS VDD VDD \_0350_
+ sky130_fd_sc_hd__nor2_1
* cell instance sky130_fd_sc_hd__nor2_1_3 r0 *1 0,0
Xsky130_fd_sc_hd__nor2_1_3 sel_q[0] net13 VSS VDD VDD \_0351_
+ sky130_fd_sc_hd__nor2_1
* cell instance sky130_fd_sc_hd__nor2_1_4 r0 *1 0,0
Xsky130_fd_sc_hd__nor2_1_4 \_0347_ \_0350_ VSS VDD VDD \_0037_
+ sky130_fd_sc_hd__nor2_1
* cell instance sky130_fd_sc_hd__nor2_1_5 r0 *1 0,0
Xsky130_fd_sc_hd__nor2_1_5 sel_q[1] net13 VSS VDD VDD \_0347_
+ sky130_fd_sc_hd__nor2_1
* cell instance sky130_fd_sc_hd__nor2_1_6 r0 *1 0,0
Xsky130_fd_sc_hd__nor2_1_6 sel_q[0] sel_q[2] VSS VDD VDD \_0330_
+ sky130_fd_sc_hd__nor2_1
* cell instance sky130_fd_sc_hd__nor2_1_7 r0 *1 0,0
Xsky130_fd_sc_hd__nor2_1_7 \_0466_ \_0482_ VSS VDD VDD \_0483_
+ sky130_fd_sc_hd__nor2_1
* cell instance sky130_fd_sc_hd__nor2_1_8 r0 *1 0,0
Xsky130_fd_sc_hd__nor2_1_8 \_0467_ \_0475_ VSS VDD VDD \_0485_
+ sky130_fd_sc_hd__nor2_1
* cell instance sky130_fd_sc_hd__nor2_1_9 r0 *1 0,0
Xsky130_fd_sc_hd__nor2_1_9 wdata[8] \_0348_ VSS VDD VDD \_0446_
+ sky130_fd_sc_hd__nor2_1
* cell instance sky130_fd_sc_hd__nor2_1_10 r0 *1 0,0
Xsky130_fd_sc_hd__nor2_1_10 \_0445_ \_0446_ VSS VDD VDD \_0207_
+ sky130_fd_sc_hd__nor2_1
* cell instance sky130_fd_sc_hd__nor2_1_11 r0 *1 0,0
Xsky130_fd_sc_hd__nor2_1_11 k_q[4] net13 VSS VDD VDD \_0445_
+ sky130_fd_sc_hd__nor2_1
* cell instance sky130_fd_sc_hd__nor2_1_12 r0 *1 0,0
Xsky130_fd_sc_hd__nor2_1_12 \_0721_ \_0759_ VSS VDD VDD \_0760_
+ sky130_fd_sc_hd__nor2_1
* cell instance sky130_fd_sc_hd__nor2_1_13 r0 *1 0,0
Xsky130_fd_sc_hd__nor2_1_13 gate_cnt[20] \_0770_ VSS VDD VDD \_0771_
+ sky130_fd_sc_hd__nor2_1
* cell instance sky130_fd_sc_hd__nor2_1_14 r0 *1 0,0
Xsky130_fd_sc_hd__nor2_1_14 k_q[4] \_0698_ VSS VDD VDD \_0713_
+ sky130_fd_sc_hd__nor2_1
* cell instance sky130_fd_sc_hd__nor2_1_15 r0 *1 0,0
Xsky130_fd_sc_hd__nor2_1_15 gate_cnt[18] \_0393_ VSS VDD VDD \_0411_
+ sky130_fd_sc_hd__nor2_1
* cell instance sky130_fd_sc_hd__nor2_1_16 r0 *1 0,0
Xsky130_fd_sc_hd__nor2_1_16 gate_en net13 VSS VDD VDD \_0320_
+ sky130_fd_sc_hd__nor2_1
* cell instance sky130_fd_sc_hd__nor2_1_17 r0 *1 0,0
Xsky130_fd_sc_hd__nor2_1_17 gate_cnt[19] \_0406_ VSS VDD VDD \_0410_
+ sky130_fd_sc_hd__nor2_1
* cell instance sky130_fd_sc_hd__nor2_1_18 r0 *1 0,0
Xsky130_fd_sc_hd__nor2_1_18 k_q[3] k_q[0] VSS VDD VDD \_0755_
+ sky130_fd_sc_hd__nor2_1
* cell instance sky130_fd_sc_hd__nor2_1_19 r0 *1 0,0
Xsky130_fd_sc_hd__nor2_1_19 u_cnt/_080_ u_cnt/_081_ VSS VDD VDD u_cnt/_082_
+ sky130_fd_sc_hd__nor2_1
* cell instance sky130_fd_sc_hd__nor2_1_20 r0 *1 0,0
Xsky130_fd_sc_hd__nor2_1_20 u_cnt/_088_ u_cnt/_067_ VSS VDD VDD u_cnt/_025_
+ sky130_fd_sc_hd__nor2_1
* cell instance sky130_fd_sc_hd__nor2_1_21 r0 *1 0,0
Xsky130_fd_sc_hd__nor2_1_21 net13 \_0455_ VSS VDD VDD \_0219_
+ sky130_fd_sc_hd__nor2_1
* cell instance sky130_fd_sc_hd__nor2_1_22 r0 *1 0,0
Xsky130_fd_sc_hd__nor2_1_22 \_0701_ \_0380_ VSS VDD VDD \_0381_
+ sky130_fd_sc_hd__nor2_1
* cell instance sky130_fd_sc_hd__nor2_1_23 r0 *1 0,0
Xsky130_fd_sc_hd__nor2_1_23 k_q[2] \_0721_ VSS VDD VDD \_0307_
+ sky130_fd_sc_hd__nor2_1
* cell instance sky130_fd_sc_hd__nor2_1_24 r0 *1 0,0
Xsky130_fd_sc_hd__nor2_1_24 u_cnt/running u_cnt/_083_ VSS VDD VDD u_cnt/_088_
+ sky130_fd_sc_hd__nor2_1
* cell instance sky130_fd_sc_hd__nor2_1_25 r0 *1 0,0
Xsky130_fd_sc_hd__nor2_1_25 gate_cnt[7] \_0728_ VSS VDD VDD \_0729_
+ sky130_fd_sc_hd__nor2_1
* cell instance sky130_fd_sc_hd__nor2_1_26 r0 *1 0,0
Xsky130_fd_sc_hd__nor2_1_26 k_q[3] k_q[4] VSS VDD VDD \_0728_
+ sky130_fd_sc_hd__nor2_1
* cell instance sky130_fd_sc_hd__nor2_1_27 r0 *1 0,0
Xsky130_fd_sc_hd__nor2_1_27 gate_cnt[17] \_0412_ VSS VDD VDD \_0413_
+ sky130_fd_sc_hd__nor2_1
* cell instance sky130_fd_sc_hd__nor2_1_28 r0 *1 0,0
Xsky130_fd_sc_hd__nor2_1_28 \_0741_ \_0717_ VSS VDD VDD \_0742_
+ sky130_fd_sc_hd__nor2_1
* cell instance sky130_fd_sc_hd__nor2_1_29 r0 *1 0,0
Xsky130_fd_sc_hd__nor2_1_29 k_q[1] k_q[0] VSS VDD VDD \_0741_
+ sky130_fd_sc_hd__nor2_1
* cell instance sky130_fd_sc_hd__nor2_1_30 r0 *1 0,0
Xsky130_fd_sc_hd__nor2_1_30 k_q[3] k_q[2] VSS VDD VDD \_0293_
+ sky130_fd_sc_hd__nor2_1
* cell instance sky130_fd_sc_hd__nor2_1_31 r0 *1 0,0
Xsky130_fd_sc_hd__nor2_1_31 \_0385_ \_0386_ VSS VDD VDD \_0158_
+ sky130_fd_sc_hd__nor2_1
* cell instance sky130_fd_sc_hd__nor2_1_32 r0 *1 0,0
Xsky130_fd_sc_hd__nor2_1_32 net13 \_0439_ VSS VDD VDD \_0186_
+ sky130_fd_sc_hd__nor2_1
* cell instance sky130_fd_sc_hd__nor2_1_33 r0 *1 0,0
Xsky130_fd_sc_hd__nor2_1_33 gate_cnt[2] \_0436_ VSS VDD VDD \_0437_
+ sky130_fd_sc_hd__nor2_1
* cell instance sky130_fd_sc_hd__nor2_1_34 r0 *1 0,0
Xsky130_fd_sc_hd__nor2_1_34 u_cnt/_073_ u_cnt/_074_ VSS VDD VDD u_cnt/_059_
+ sky130_fd_sc_hd__nor2_1
* cell instance sky130_fd_sc_hd__nor2_1_35 r0 *1 0,0
Xsky130_fd_sc_hd__nor2_1_35 \_0695_ \_0747_ VSS VDD VDD \_0748_
+ sky130_fd_sc_hd__nor2_1
* cell instance sky130_fd_sc_hd__nor2_1_36 r0 *1 0,0
Xsky130_fd_sc_hd__nor2_1_36 gate_cnt[6] \_0391_ VSS VDD VDD \_0431_
+ sky130_fd_sc_hd__nor2_1
* cell instance sky130_fd_sc_hd__nor2_1_37 r0 *1 0,0
Xsky130_fd_sc_hd__nor2_1_37 gate_cnt[9] \_0415_ VSS VDD VDD \_0427_
+ sky130_fd_sc_hd__nor2_1
* cell instance sky130_fd_sc_hd__nor2_1_38 r0 *1 0,0
Xsky130_fd_sc_hd__nor2_1_38 gate_cnt[3] \_0390_ VSS VDD VDD \_0435_
+ sky130_fd_sc_hd__nor2_1
* cell instance sky130_fd_sc_hd__nor2_1_39 r0 *1 0,0
Xsky130_fd_sc_hd__nor2_1_39 u_cnt/_042_ u_cnt/_044_ VSS VDD VDD u_cnt/_015_
+ sky130_fd_sc_hd__nor2_1
* cell instance sky130_fd_sc_hd__nor2_1_40 r0 *1 0,0
Xsky130_fd_sc_hd__nor2_1_40 \_0368_ \_0369_ VSS VDD VDD \_0370_
+ sky130_fd_sc_hd__nor2_1
* cell instance sky130_fd_sc_hd__nor2_1_41 r0 *1 0,0
Xsky130_fd_sc_hd__nor2_1_41 \_0421_ \_0426_ VSS VDD VDD \_0176_
+ sky130_fd_sc_hd__nor2_1
* cell instance sky130_fd_sc_hd__nor2_1_42 r0 *1 0,0
Xsky130_fd_sc_hd__nor2_1_42 \_0418_ \_0420_ VSS VDD VDD \_0172_
+ sky130_fd_sc_hd__nor2_1
* cell instance sky130_fd_sc_hd__nor2_1_43 r0 *1 0,0
Xsky130_fd_sc_hd__nor2_1_43 \_0422_ \_0425_ VSS VDD VDD \_0175_
+ sky130_fd_sc_hd__nor2_1
* cell instance sky130_fd_sc_hd__nor2_4_0 r0 *1 0,0
Xsky130_fd_sc_hd__nor2_4_0 addr[3] \_0495_ VSS VDD VDD \_0626_
+ sky130_fd_sc_hd__nor2_4
* cell instance sky130_fd_sc_hd__nor2b_1_0 r0 *1 0,0
Xsky130_fd_sc_hd__nor2b_1_0 addr[3] net20 VSS VDD VDD \_0667_
+ sky130_fd_sc_hd__nor2b_1
* cell instance sky130_fd_sc_hd__nor2b_1_1 r0 *1 0,0
Xsky130_fd_sc_hd__nor2b_1_1 k_q[4] \_0715_ VSS VDD VDD \_0716_
+ sky130_fd_sc_hd__nor2b_1
* cell instance sky130_fd_sc_hd__nor2b_1_2 r0 *1 0,0
Xsky130_fd_sc_hd__nor2b_1_2 cnt_o[5] u_cnt/running VSS VDD VDD u_cnt/_065_
+ sky130_fd_sc_hd__nor2b_1
* cell instance sky130_fd_sc_hd__nor2b_1_3 r0 *1 0,0
Xsky130_fd_sc_hd__nor2b_1_3 \_0368_ \_0416_ VSS VDD VDD \_0417_
+ sky130_fd_sc_hd__nor2b_1
* cell instance sky130_fd_sc_hd__nor3_1_0 r0 *1 0,0
Xsky130_fd_sc_hd__nor3_1_0 \_0468_ \_0466_ \_0467_ VSS VDD VDD \_0338_
+ sky130_fd_sc_hd__nor3_1
* cell instance sky130_fd_sc_hd__nor3_1_1 r0 *1 0,0
Xsky130_fd_sc_hd__nor3_1_1 sel_q[0] sel_q[2] sel_q[1] VSS VDD VDD \_0332_
+ sky130_fd_sc_hd__nor3_1
* cell instance sky130_fd_sc_hd__nor3_1_2 r0 *1 0,0
Xsky130_fd_sc_hd__nor3_1_2 net13 \_0396_ \_0401_ VSS VDD VDD \_0161_
+ sky130_fd_sc_hd__nor3_1
* cell instance sky130_fd_sc_hd__nor3_1_3 r0 *1 0,0
Xsky130_fd_sc_hd__nor3_1_3 net13 \_0394_ \_0404_ VSS VDD VDD \_0163_
+ sky130_fd_sc_hd__nor3_1
* cell instance sky130_fd_sc_hd__nor3_1_4 r0 *1 0,0
Xsky130_fd_sc_hd__nor3_1_4 net13 \_0403_ \_0407_ VSS VDD VDD \_0165_
+ sky130_fd_sc_hd__nor3_1
* cell instance sky130_fd_sc_hd__nor3_1_5 r0 *1 0,0
Xsky130_fd_sc_hd__nor3_1_5 net13 \_0408_ \_0409_ VSS VDD VDD \_0166_
+ sky130_fd_sc_hd__nor3_1
* cell instance sky130_fd_sc_hd__nor3_1_6 r0 *1 0,0
Xsky130_fd_sc_hd__nor3_1_6 net13 \_0406_ \_0411_ VSS VDD VDD \_0168_
+ sky130_fd_sc_hd__nor3_1
* cell instance sky130_fd_sc_hd__nor3_1_7 r0 *1 0,0
Xsky130_fd_sc_hd__nor3_1_7 \_0710_ \_0712_ \_0719_ VSS VDD VDD \_0720_
+ sky130_fd_sc_hd__nor3_1
* cell instance sky130_fd_sc_hd__nor3_1_8 r0 *1 0,0
Xsky130_fd_sc_hd__nor3_1_8 net13 \_0393_ \_0413_ VSS VDD VDD \_0169_
+ sky130_fd_sc_hd__nor3_1
* cell instance sky130_fd_sc_hd__nor3_1_9 r0 *1 0,0
Xsky130_fd_sc_hd__nor3_1_9 net13 \_0436_ \_0438_ VSS VDD VDD \_0185_
+ sky130_fd_sc_hd__nor3_1
* cell instance sky130_fd_sc_hd__nor3_1_10 r0 *1 0,0
Xsky130_fd_sc_hd__nor3_1_10 k_q[3] k_q[2] k_q[1] VSS VDD VDD \_0295_
+ sky130_fd_sc_hd__nor3_1
* cell instance sky130_fd_sc_hd__nor3_1_11 r0 *1 0,0
Xsky130_fd_sc_hd__nor3_1_11 net13 \_0412_ \_0414_ VSS VDD VDD \_0170_
+ sky130_fd_sc_hd__nor3_1
* cell instance sky130_fd_sc_hd__nor3_1_12 r0 *1 0,0
Xsky130_fd_sc_hd__nor3_1_12 \_0371_ \_0372_ \_0373_ VSS VDD VDD \_0374_
+ sky130_fd_sc_hd__nor3_1
* cell instance sky130_fd_sc_hd__nor3_1_13 r0 *1 0,0
Xsky130_fd_sc_hd__nor3_1_13 k_q[1] k_q[0] k_q[4] VSS VDD VDD \_0747_
+ sky130_fd_sc_hd__nor3_1
* cell instance sky130_fd_sc_hd__nor3_1_14 r0 *1 0,0
Xsky130_fd_sc_hd__nor3_1_14 net13 \_0390_ \_0437_ VSS VDD VDD \_0184_
+ sky130_fd_sc_hd__nor3_1
* cell instance sky130_fd_sc_hd__nor3_1_15 r0 *1 0,0
Xsky130_fd_sc_hd__nor3_1_15 u_cnt/_069_ u_cnt/_070_ u_cnt/_076_ VSS VDD VDD
+ u_cnt/_036_ sky130_fd_sc_hd__nor3_1
* cell instance sky130_fd_sc_hd__nor3_1_16 r0 *1 0,0
Xsky130_fd_sc_hd__nor3_1_16 net13 \_0428_ \_0431_ VSS VDD VDD \_0180_
+ sky130_fd_sc_hd__nor3_1
* cell instance sky130_fd_sc_hd__nor3_1_17 r0 *1 0,0
Xsky130_fd_sc_hd__nor3_1_17 net13 \_0415_ \_0429_ VSS VDD VDD \_0178_
+ sky130_fd_sc_hd__nor3_1
* cell instance sky130_fd_sc_hd__nor3_1_18 r0 *1 0,0
Xsky130_fd_sc_hd__nor3_1_18 net13 \_0416_ \_0427_ VSS VDD VDD \_0177_
+ sky130_fd_sc_hd__nor3_1
* cell instance sky130_fd_sc_hd__nor3_1_19 r0 *1 0,0
Xsky130_fd_sc_hd__nor3_1_19 net13 \_0391_ \_0433_ VSS VDD VDD \_0181_
+ sky130_fd_sc_hd__nor3_1
* cell instance sky130_fd_sc_hd__nor3_1_20 r0 *1 0,0
Xsky130_fd_sc_hd__nor3_1_20 net13 \_0432_ \_0435_ VSS VDD VDD \_0183_
+ sky130_fd_sc_hd__nor3_1
* cell instance sky130_fd_sc_hd__nor3_1_21 r0 *1 0,0
Xsky130_fd_sc_hd__nor3_1_21 net13 \_0417_ \_0423_ VSS VDD VDD \_0173_
+ sky130_fd_sc_hd__nor3_1
* cell instance sky130_fd_sc_hd__nor3_2_0 r0 *1 0,0
Xsky130_fd_sc_hd__nor3_2_0 u_cnt/_088_ u_cnt/_038_ u_cnt/_040_ VSS VDD VDD
+ u_cnt/_012_ sky130_fd_sc_hd__nor3_2
* cell instance sky130_fd_sc_hd__nor3_2_1 r0 *1 0,0
Xsky130_fd_sc_hd__nor3_2_1 u_cnt/_088_ u_cnt/_086_ u_cnt/_093_ VSS VDD VDD
+ u_cnt/_001_ sky130_fd_sc_hd__nor3_2
* cell instance sky130_fd_sc_hd__nor3b_1_0 r0 *1 0,0
Xsky130_fd_sc_hd__nor3b_1_0 \_0468_ \_0466_ addr[2] VSS VDD VDD \_0472_
+ sky130_fd_sc_hd__nor3b_1
* cell instance sky130_fd_sc_hd__nor3b_1_1 r0 *1 0,0
Xsky130_fd_sc_hd__nor3b_1_1 \_0468_ \_0467_ \_0466_ VSS VDD VDD \_0500_
+ sky130_fd_sc_hd__nor3b_1
* cell instance sky130_fd_sc_hd__nor3b_1_2 r0 *1 0,0
Xsky130_fd_sc_hd__nor3b_1_2 \_0466_ \_0467_ \_0468_ VSS VDD VDD \_0493_
+ sky130_fd_sc_hd__nor3b_1
* cell instance sky130_fd_sc_hd__nor3b_1_3 r0 *1 0,0
Xsky130_fd_sc_hd__nor3b_1_3 sel_q[2] sel_q[1] sel_q[0] VSS VDD VDD \_0333_
+ sky130_fd_sc_hd__nor3b_1
* cell instance sky130_fd_sc_hd__nor3b_1_4 r0 *1 0,0
Xsky130_fd_sc_hd__nor3b_1_4 sel_q[0] sel_q[1] sel_q[2] VSS VDD VDD \_0335_
+ sky130_fd_sc_hd__nor3b_1
* cell instance sky130_fd_sc_hd__nor3b_1_5 r0 *1 0,0
Xsky130_fd_sc_hd__nor3b_1_5 net13 \_0381_ \_0384_ VSS VDD VDD \_0157_
+ sky130_fd_sc_hd__nor3b_1
* cell instance sky130_fd_sc_hd__nor4_1_0 r0 *1 0,0
Xsky130_fd_sc_hd__nor4_1_0 \_0375_ \_0376_ \_0377_ \_0378_ VSS VDD VDD \_0379_
+ sky130_fd_sc_hd__nor4_1
* cell instance sky130_fd_sc_hd__nor4_1_1 r0 *1 0,0
Xsky130_fd_sc_hd__nor4_1_1 gate_cnt[31] \_0729_ \_0731_ \_0735_ VSS VDD VDD
+ \_0736_ sky130_fd_sc_hd__nor4_1
* cell instance sky130_fd_sc_hd__nor4_1_2 r0 *1 0,0
Xsky130_fd_sc_hd__nor4_1_2 \_0739_ \_0744_ \_0753_ \_0765_ VSS VDD VDD \_0766_
+ sky130_fd_sc_hd__nor4_1
* cell instance sky130_fd_sc_hd__nor4_4_0 r0 *1 0,0
Xsky130_fd_sc_hd__nor4_4_0 u_cnt/_071_ u_cnt/_072_ u_cnt/_073_ u_cnt/_074_ VSS
+ VDD VDD u_cnt/_075_ sky130_fd_sc_hd__nor4_4
* cell instance sky130_fd_sc_hd__nor4_4_1 r0 *1 0,0
Xsky130_fd_sc_hd__nor4_4_1 u_cnt/_069_ u_cnt/_070_ u_cnt/_076_ u_cnt/_077_ VSS
+ VDD VDD u_cnt/_078_ sky130_fd_sc_hd__nor4_4
* cell instance sky130_fd_sc_hd__nor4bb_1_0 r0 *1 0,0
Xsky130_fd_sc_hd__nor4bb_1_0 busy_r \_0313_ \_0314_ wdata[0] VSS VDD VDD
+ \_0315_ sky130_fd_sc_hd__nor4bb_1
* cell instance sky130_fd_sc_hd__o2111ai_1_0 r0 *1 0,0
Xsky130_fd_sc_hd__o2111ai_1_0 gate_cnt[6] \_0722_ \_0725_ \_0727_ \_0736_ VSS
+ VDD VDD \_0737_ sky130_fd_sc_hd__o2111ai_1
* cell instance sky130_fd_sc_hd__o2111ai_1_1 r0 *1 0,0
Xsky130_fd_sc_hd__o2111ai_1_1 gate_cnt[30] \_0754_ \_0756_ \_0761_ \_0764_ VSS
+ VDD VDD \_0765_ sky130_fd_sc_hd__o2111ai_1
* cell instance sky130_fd_sc_hd__o2111ai_1_2 r0 *1 0,0
Xsky130_fd_sc_hd__o2111ai_1_2 u_cnt/_088_ u_cnt/_084_ u_cnt/_078_ cnt_o[17]
+ cnt_o[18] VSS VDD VDD u_cnt/_029_ sky130_fd_sc_hd__o2111ai_1
* cell instance sky130_fd_sc_hd__o2111ai_1_3 r0 *1 0,0
Xsky130_fd_sc_hd__o2111ai_1_3 gate_cnt[8] \_0746_ \_0749_ \_0751_ \_0752_ VSS
+ VDD VDD \_0753_ sky130_fd_sc_hd__o2111ai_1
* cell instance sky130_fd_sc_hd__o211ai_1_0 r0 *1 0,0
Xsky130_fd_sc_hd__o211ai_1_0 u_cnt/_088_ u_cnt/_084_ u_cnt/_101_ cnt_o[21] VSS
+ VDD VDD u_cnt/_102_ sky130_fd_sc_hd__o211ai_1
* cell instance sky130_fd_sc_hd__o211ai_1_1 r0 *1 0,0
Xsky130_fd_sc_hd__o211ai_1_1 k_q[2] k_q[1] k_q[4] k_q[3] VSS VDD VDD \_0740_
+ sky130_fd_sc_hd__o211ai_1
* cell instance sky130_fd_sc_hd__o211ai_1_2 r0 *1 0,0
Xsky130_fd_sc_hd__o211ai_1_2 u_cnt/_088_ u_cnt/_084_ u_cnt/_047_ cnt_o[9] VSS
+ VDD VDD u_cnt/_053_ sky130_fd_sc_hd__o211ai_1
* cell instance sky130_fd_sc_hd__o211ai_1_3 r0 *1 0,0
Xsky130_fd_sc_hd__o211ai_1_3 u_cnt/_088_ u_cnt/_084_ u_cnt/_048_ cnt_o[11] VSS
+ VDD VDD u_cnt/_049_ sky130_fd_sc_hd__o211ai_1
* cell instance sky130_fd_sc_hd__o21a_1_0 r0 *1 0,0
Xsky130_fd_sc_hd__o21a_1_0 gate_cnt[22] \_0403_ \_0405_ VSS VDD VDD \_0164_
+ sky130_fd_sc_hd__o21a_1
* cell instance sky130_fd_sc_hd__o21a_1_1 r0 *1 0,0
Xsky130_fd_sc_hd__o21a_1_1 gate_cnt[24] \_0394_ \_0402_ VSS VDD VDD \_0162_
+ sky130_fd_sc_hd__o21a_1
* cell instance sky130_fd_sc_hd__o21a_1_2 r0 *1 0,0
Xsky130_fd_sc_hd__o21a_1_2 k_q[1] k_q[0] k_q[2] VSS VDD VDD \_0759_
+ sky130_fd_sc_hd__o21a_1
* cell instance sky130_fd_sc_hd__o21a_1_3 r0 *1 0,0
Xsky130_fd_sc_hd__o21a_1_3 k_q[3] \_0759_ k_q[4] VSS VDD VDD \_0769_
+ sky130_fd_sc_hd__o21a_1
* cell instance sky130_fd_sc_hd__o21a_1_4 r0 *1 0,0
Xsky130_fd_sc_hd__o21a_1_4 cnt_o[1] u_cnt/_097_ u_cnt/_099_ VSS VDD VDD
+ u_cnt/_003_ sky130_fd_sc_hd__o21a_1
* cell instance sky130_fd_sc_hd__o21a_1_5 r0 *1 0,0
Xsky130_fd_sc_hd__o21a_1_5 cnt_o[16] u_cnt/_038_ u_cnt/_039_ VSS VDD VDD
+ u_cnt/_011_ sky130_fd_sc_hd__o21a_1
* cell instance sky130_fd_sc_hd__o21a_1_6 r0 *1 0,0
Xsky130_fd_sc_hd__o21a_1_6 cnt_o[14] u_cnt/_042_ u_cnt/_043_ VSS VDD VDD
+ u_cnt/_014_ sky130_fd_sc_hd__o21a_1
* cell instance sky130_fd_sc_hd__o21a_1_7 r0 *1 0,0
Xsky130_fd_sc_hd__o21a_1_7 u_cnt/_090_ u_cnt/_065_ u_cnt/_066_ VSS VDD VDD
+ u_cnt/_024_ sky130_fd_sc_hd__o21a_1
* cell instance sky130_fd_sc_hd__o21a_1_8 r0 *1 0,0
Xsky130_fd_sc_hd__o21a_1_8 cnt_o[4] u_cnt/_086_ u_cnt/_090_ VSS VDD VDD
+ u_cnt/_000_ sky130_fd_sc_hd__o21a_1
* cell instance sky130_fd_sc_hd__o21ai_0_0 r0 *1 0,0
Xsky130_fd_sc_hd__o21ai_0_0 \_0468_ addr[1] addr[2] VSS VDD VDD \_0490_
+ sky130_fd_sc_hd__o21ai_0
* cell instance sky130_fd_sc_hd__o21ai_0_1 r0 *1 0,0
Xsky130_fd_sc_hd__o21ai_0_1 wdata[1] wdata[2] wdata[3] VSS VDD VDD \_0314_
+ sky130_fd_sc_hd__o21ai_0
* cell instance sky130_fd_sc_hd__o21ai_0_2 r0 *1 0,0
Xsky130_fd_sc_hd__o21ai_0_2 tog_s2 tog_s3 busy_r VSS VDD VDD \_0342_
+ sky130_fd_sc_hd__o21ai_0
* cell instance sky130_fd_sc_hd__o21ai_0_3 r0 *1 0,0
Xsky130_fd_sc_hd__o21ai_0_3 \_0449_ \_0343_ \_0348_ VSS VDD VDD \_0210_
+ sky130_fd_sc_hd__o21ai_0
* cell instance sky130_fd_sc_hd__o21ai_0_4 r0 *1 0,0
Xsky130_fd_sc_hd__o21ai_0_4 \_0491_ \_0656_ \_0660_ VSS VDD VDD rdata[4]
+ sky130_fd_sc_hd__o21ai_0
* cell instance sky130_fd_sc_hd__o21ai_0_5 r0 *1 0,0
Xsky130_fd_sc_hd__o21ai_0_5 \_0491_ \_0625_ \_0631_ VSS VDD VDD rdata[8]
+ sky130_fd_sc_hd__o21ai_0
* cell instance sky130_fd_sc_hd__o21ai_0_6 r0 *1 0,0
Xsky130_fd_sc_hd__o21ai_0_6 k_q[2] k_q[1] k_q[3] VSS VDD VDD \_0762_
+ sky130_fd_sc_hd__o21ai_0
* cell instance sky130_fd_sc_hd__o21ai_0_7 r0 *1 0,0
Xsky130_fd_sc_hd__o21ai_0_7 k_q[3] k_q[2] k_q[4] VSS VDD VDD \_0303_
+ sky130_fd_sc_hd__o21ai_0
* cell instance sky130_fd_sc_hd__o21ai_0_8 r0 *1 0,0
Xsky130_fd_sc_hd__o21ai_0_8 k_q[4] \_0723_ gate_cnt[9] VSS VDD VDD \_0726_
+ sky130_fd_sc_hd__o21ai_0
* cell instance sky130_fd_sc_hd__o21ai_0_9 r0 *1 0,0
Xsky130_fd_sc_hd__o21ai_0_9 k_q[3] \_0759_ k_q[4] VSS VDD VDD \_0302_
+ sky130_fd_sc_hd__o21ai_0
* cell instance sky130_fd_sc_hd__o21ai_0_10 r0 *1 0,0
Xsky130_fd_sc_hd__o21ai_0_10 \_0760_ \_0769_ gate_cnt[4] VSS VDD VDD \_0770_
+ sky130_fd_sc_hd__o21ai_0
* cell instance sky130_fd_sc_hd__o21ai_0_11 r0 *1 0,0
Xsky130_fd_sc_hd__o21ai_0_11 gate_cnt[24] \_0300_ \_0305_ VSS VDD VDD \_0306_
+ sky130_fd_sc_hd__o21ai_0
* cell instance sky130_fd_sc_hd__o21ai_0_12 r0 *1 0,0
Xsky130_fd_sc_hd__o21ai_0_12 gate_cnt[30] \_0381_ \_0348_ VSS VDD VDD \_0383_
+ sky130_fd_sc_hd__o21ai_0
* cell instance sky130_fd_sc_hd__o21ai_0_13 r0 *1 0,0
Xsky130_fd_sc_hd__o21ai_0_13 k_q[3] \_0705_ k_q[4] VSS VDD VDD \_0711_
+ sky130_fd_sc_hd__o21ai_0
* cell instance sky130_fd_sc_hd__o21ai_0_14 r0 *1 0,0
Xsky130_fd_sc_hd__o21ai_0_14 \_0755_ \_0711_ gate_cnt[22] VSS VDD VDD \_0756_
+ sky130_fd_sc_hd__o21ai_0
* cell instance sky130_fd_sc_hd__o21ai_0_15 r0 *1 0,0
Xsky130_fd_sc_hd__o21ai_0_15 u_cnt/_088_ u_cnt/_084_ u_cnt/_101_ VSS VDD VDD
+ u_cnt/_105_ sky130_fd_sc_hd__o21ai_0
* cell instance sky130_fd_sc_hd__o21ai_0_16 r0 *1 0,0
Xsky130_fd_sc_hd__o21ai_0_16 k_q[0] \_0706_ gate_cnt[29] VSS VDD VDD \_0754_
+ sky130_fd_sc_hd__o21ai_0
* cell instance sky130_fd_sc_hd__o21ai_0_17 r0 *1 0,0
Xsky130_fd_sc_hd__o21ai_0_17 cnt_o[23] u_cnt/_103_ u_cnt/_095_ VSS VDD VDD
+ u_cnt/_104_ sky130_fd_sc_hd__o21ai_0
* cell instance sky130_fd_sc_hd__o21ai_0_18 r0 *1 0,0
Xsky130_fd_sc_hd__o21ai_0_18 u_cnt/_030_ u_cnt/_096_ u_cnt/_095_ VSS VDD VDD
+ u_cnt/_031_ sky130_fd_sc_hd__o21ai_0
* cell instance sky130_fd_sc_hd__o21ai_0_19 r0 *1 0,0
Xsky130_fd_sc_hd__o21ai_0_19 u_cnt/_088_ u_cnt/_084_ u_cnt/_078_ VSS VDD VDD
+ u_cnt/_035_ sky130_fd_sc_hd__o21ai_0
* cell instance sky130_fd_sc_hd__o21ai_0_20 r0 *1 0,0
Xsky130_fd_sc_hd__o21ai_0_20 u_cnt/_060_ u_cnt/_096_ u_cnt/_095_ VSS VDD VDD
+ u_cnt/_061_ sky130_fd_sc_hd__o21ai_0
* cell instance sky130_fd_sc_hd__o21ai_0_21 r0 *1 0,0
Xsky130_fd_sc_hd__o21ai_0_21 u_cnt/_088_ u_cnt/_084_ u_cnt/_059_ VSS VDD VDD
+ u_cnt/_064_ sky130_fd_sc_hd__o21ai_0
* cell instance sky130_fd_sc_hd__o21ai_0_22 r0 *1 0,0
Xsky130_fd_sc_hd__o21ai_0_22 gate_cnt[25] \_0740_ \_0743_ VSS VDD VDD \_0744_
+ sky130_fd_sc_hd__o21ai_0
* cell instance sky130_fd_sc_hd__o21ai_0_23 r0 *1 0,0
Xsky130_fd_sc_hd__o21ai_0_23 k_q[3] \_0745_ k_q[4] VSS VDD VDD \_0750_
+ sky130_fd_sc_hd__o21ai_0
* cell instance sky130_fd_sc_hd__o21ai_0_24 r0 *1 0,0
Xsky130_fd_sc_hd__o21ai_0_24 u_cnt/_076_ u_cnt/_096_ u_cnt/_095_ VSS VDD VDD
+ u_cnt/_050_ sky130_fd_sc_hd__o21ai_0
* cell instance sky130_fd_sc_hd__o21ai_0_25 r0 *1 0,0
Xsky130_fd_sc_hd__o21ai_0_25 u_cnt/_088_ u_cnt/_084_ u_cnt/_075_ VSS VDD VDD
+ u_cnt/_058_ sky130_fd_sc_hd__o21ai_0
* cell instance sky130_fd_sc_hd__o21ai_0_26 r0 *1 0,0
Xsky130_fd_sc_hd__o21ai_0_26 u_cnt/_046_ u_cnt/_096_ u_cnt/_095_ VSS VDD VDD
+ u_cnt/_054_ sky130_fd_sc_hd__o21ai_0
* cell instance sky130_fd_sc_hd__o21ai_0_27 r0 *1 0,0
Xsky130_fd_sc_hd__o21ai_0_27 gate_cnt[7] \_0428_ \_0348_ VSS VDD VDD \_0430_
+ sky130_fd_sc_hd__o21ai_0
* cell instance sky130_fd_sc_hd__o21ai_0_28 r0 *1 0,0
Xsky130_fd_sc_hd__o21ai_0_28 gate_cnt[10] \_0416_ \_0348_ VSS VDD VDD \_0426_
+ sky130_fd_sc_hd__o21ai_0
* cell instance sky130_fd_sc_hd__o21ai_0_29 r0 *1 0,0
Xsky130_fd_sc_hd__o21ai_0_29 gate_cnt[4] \_0432_ \_0348_ VSS VDD VDD \_0434_
+ sky130_fd_sc_hd__o21ai_0
* cell instance sky130_fd_sc_hd__o21ai_0_30 r0 *1 0,0
Xsky130_fd_sc_hd__o21ai_0_30 gate_cnt[15] \_0392_ \_0348_ VSS VDD VDD \_0419_
+ sky130_fd_sc_hd__o21ai_0
* cell instance sky130_fd_sc_hd__o21ai_0_31 r0 *1 0,0
Xsky130_fd_sc_hd__o21ai_0_31 gate_cnt[14] \_0417_ \_0348_ VSS VDD VDD \_0420_
+ sky130_fd_sc_hd__o21ai_0
* cell instance sky130_fd_sc_hd__o21ai_0_32 r0 *1 0,0
Xsky130_fd_sc_hd__o21ai_0_32 gate_cnt[11] \_0421_ \_0348_ VSS VDD VDD \_0425_
+ sky130_fd_sc_hd__o21ai_0
* cell instance sky130_fd_sc_hd__o21ai_0_33 r0 *1 0,0
Xsky130_fd_sc_hd__o21ai_0_33 gate_cnt[12] \_0422_ \_0348_ VSS VDD VDD \_0424_
+ sky130_fd_sc_hd__o21ai_0
* cell instance sky130_fd_sc_hd__o21ai_1_0 r0 *1 0,0
Xsky130_fd_sc_hd__o21ai_1_0 \_0466_ \_0467_ \_0469_ VSS VDD VDD \_0470_
+ sky130_fd_sc_hd__o21ai_1
* cell instance sky130_fd_sc_hd__o21bai_1_0 r0 *1 0,0
Xsky130_fd_sc_hd__o21bai_1_0 \_0755_ \_0711_ \_0722_ VSS VDD VDD \_0768_
+ sky130_fd_sc_hd__o21bai_1
* cell instance sky130_fd_sc_hd__o221ai_1_0 r0 *1 0,0
Xsky130_fd_sc_hd__o221ai_1_0 gate_cnt[1] \_0713_ \_0716_ gate_cnt[2] \_0718_
+ VSS VDD VDD \_0719_ sky130_fd_sc_hd__o221ai_1
* cell instance sky130_fd_sc_hd__o22ai_1_0 r0 *1 0,0
Xsky130_fd_sc_hd__o22ai_1_0 \_0491_ \_0569_ \_0573_ net18 VSS VDD VDD rdata[15]
+ sky130_fd_sc_hd__o22ai_1
* cell instance sky130_fd_sc_hd__o22ai_1_1 r0 *1 0,0
Xsky130_fd_sc_hd__o22ai_1_1 net18 \_0593_ \_0597_ \_0491_ VSS VDD VDD rdata[12]
+ sky130_fd_sc_hd__o22ai_1
* cell instance sky130_fd_sc_hd__o22ai_1_2 r0 *1 0,0
Xsky130_fd_sc_hd__o22ai_1_2 net18 \_0489_ \_0491_ \_0506_ VSS VDD VDD rdata[22]
+ sky130_fd_sc_hd__o22ai_1
* cell instance sky130_fd_sc_hd__o22ai_1_3 r0 *1 0,0
Xsky130_fd_sc_hd__o22ai_1_3 \_0491_ \_0552_ \_0556_ net18 VSS VDD VDD rdata[17]
+ sky130_fd_sc_hd__o22ai_1
* cell instance sky130_fd_sc_hd__o22ai_1_4 r0 *1 0,0
Xsky130_fd_sc_hd__o22ai_1_4 net18 \_0532_ \_0539_ \_0491_ VSS VDD VDD rdata[19]
+ sky130_fd_sc_hd__o22ai_1
* cell instance sky130_fd_sc_hd__o22ai_1_5 r0 *1 0,0
Xsky130_fd_sc_hd__o22ai_1_5 \_0470_ \_0585_ \_0589_ \_0491_ VSS VDD VDD
+ rdata[13] sky130_fd_sc_hd__o22ai_1
* cell instance sky130_fd_sc_hd__o22ai_1_6 r0 *1 0,0
Xsky130_fd_sc_hd__o22ai_1_6 \_0491_ \_0324_ \_0328_ \_0470_ VSS VDD VDD
+ rdata[23] sky130_fd_sc_hd__o22ai_1
* cell instance sky130_fd_sc_hd__o22ai_1_7 r0 *1 0,0
Xsky130_fd_sc_hd__o22ai_1_7 \_0491_ \_0609_ \_0613_ net18 VSS VDD VDD rdata[10]
+ sky130_fd_sc_hd__o22ai_1
* cell instance sky130_fd_sc_hd__o22ai_1_8 r0 *1 0,0
Xsky130_fd_sc_hd__o22ai_1_8 \_0491_ \_0543_ \_0547_ net18 VSS VDD VDD rdata[18]
+ sky130_fd_sc_hd__o22ai_1
* cell instance sky130_fd_sc_hd__o22ai_1_9 r0 *1 0,0
Xsky130_fd_sc_hd__o22ai_1_9 \_0470_ \_0523_ \_0527_ \_0491_ VSS VDD VDD
+ rdata[20] sky130_fd_sc_hd__o22ai_1
* cell instance sky130_fd_sc_hd__o22ai_1_10 r0 *1 0,0
Xsky130_fd_sc_hd__o22ai_1_10 \_0491_ \_0577_ \_0581_ \_0470_ VSS VDD VDD
+ rdata[14] sky130_fd_sc_hd__o22ai_1
* cell instance sky130_fd_sc_hd__o22ai_1_11 r0 *1 0,0
Xsky130_fd_sc_hd__o22ai_1_11 \_0470_ \_0513_ \_0518_ \_0491_ VSS VDD VDD
+ rdata[21] sky130_fd_sc_hd__o22ai_1
* cell instance sky130_fd_sc_hd__o22ai_1_12 r0 *1 0,0
Xsky130_fd_sc_hd__o22ai_1_12 \_0470_ \_0560_ \_0564_ \_0491_ VSS VDD VDD
+ rdata[16] sky130_fd_sc_hd__o22ai_1
* cell instance sky130_fd_sc_hd__o22ai_1_13 r0 *1 0,0
Xsky130_fd_sc_hd__o22ai_1_13 \_0491_ \_0617_ \_0621_ \_0470_ VSS VDD VDD
+ rdata[9] sky130_fd_sc_hd__o22ai_1
* cell instance sky130_fd_sc_hd__o22ai_1_14 r0 *1 0,0
Xsky130_fd_sc_hd__o22ai_1_14 net18 \_0601_ \_0605_ \_0491_ VSS VDD VDD
+ rdata[11] sky130_fd_sc_hd__o22ai_1
* cell instance sky130_fd_sc_hd__o311ai_0_0 r0 *1 0,0
Xsky130_fd_sc_hd__o311ai_0_0 k_q[3] k_q[2] k_q[0] k_q[4] \_0698_ VSS VDD VDD
+ \_0301_ sky130_fd_sc_hd__o311ai_0
* cell instance sky130_fd_sc_hd__o32a_1_0 r0 *1 0,0
Xsky130_fd_sc_hd__o32a_1_0 \_0757_ gate_cnt[18] \_0758_ \_0760_ gate_cnt[4] VSS
+ VDD VDD \_0761_ sky130_fd_sc_hd__o32a_1
* cell instance sky130_fd_sc_hd__or2_2_0 r0 *1 0,0
Xsky130_fd_sc_hd__or2_2_0 k_q[3] k_q[4] VSS VDD VDD \_0721_
+ sky130_fd_sc_hd__or2_2
* cell instance sky130_fd_sc_hd__or3_1_0 r0 *1 0,0
Xsky130_fd_sc_hd__or3_1_0 addr[0] addr[1] addr[2] VSS VDD VDD \_0495_
+ sky130_fd_sc_hd__or3_1
* cell instance sky130_fd_sc_hd__or3_1_1 r0 *1 0,0
Xsky130_fd_sc_hd__or3_1_1 k_q[3] k_q[2] k_q[1] VSS VDD VDD \_0698_
+ sky130_fd_sc_hd__or3_1
* cell instance sky130_fd_sc_hd__or3_1_2 r0 *1 0,0
Xsky130_fd_sc_hd__or3_1_2 k_q[2] k_q[1] k_q[0] VSS VDD VDD \_0745_
+ sky130_fd_sc_hd__or3_1
* cell instance sky130_fd_sc_hd__tapvpwrvgnd_1_0 r0 *1 0,0
Xsky130_fd_sc_hd__tapvpwrvgnd_1_0 VSS VDD sky130_fd_sc_hd__tapvpwrvgnd_1
* cell instance sky130_fd_sc_hd__tapvpwrvgnd_1_1 r0 *1 0,0
Xsky130_fd_sc_hd__tapvpwrvgnd_1_1 VSS VDD sky130_fd_sc_hd__tapvpwrvgnd_1
* cell instance sky130_fd_sc_hd__tapvpwrvgnd_1_2 r0 *1 0,0
Xsky130_fd_sc_hd__tapvpwrvgnd_1_2 VSS VDD sky130_fd_sc_hd__tapvpwrvgnd_1
* cell instance sky130_fd_sc_hd__tapvpwrvgnd_1_3 r0 *1 0,0
Xsky130_fd_sc_hd__tapvpwrvgnd_1_3 VSS VDD sky130_fd_sc_hd__tapvpwrvgnd_1
* cell instance sky130_fd_sc_hd__tapvpwrvgnd_1_4 r0 *1 0,0
Xsky130_fd_sc_hd__tapvpwrvgnd_1_4 VSS VDD sky130_fd_sc_hd__tapvpwrvgnd_1
* cell instance sky130_fd_sc_hd__tapvpwrvgnd_1_5 r0 *1 0,0
Xsky130_fd_sc_hd__tapvpwrvgnd_1_5 VSS VDD sky130_fd_sc_hd__tapvpwrvgnd_1
* cell instance sky130_fd_sc_hd__tapvpwrvgnd_1_6 r0 *1 0,0
Xsky130_fd_sc_hd__tapvpwrvgnd_1_6 VSS VDD sky130_fd_sc_hd__tapvpwrvgnd_1
* cell instance sky130_fd_sc_hd__tapvpwrvgnd_1_7 r0 *1 0,0
Xsky130_fd_sc_hd__tapvpwrvgnd_1_7 VSS VDD sky130_fd_sc_hd__tapvpwrvgnd_1
* cell instance sky130_fd_sc_hd__tapvpwrvgnd_1_8 r0 *1 0,0
Xsky130_fd_sc_hd__tapvpwrvgnd_1_8 VSS VDD sky130_fd_sc_hd__tapvpwrvgnd_1
* cell instance sky130_fd_sc_hd__tapvpwrvgnd_1_9 r0 *1 0,0
Xsky130_fd_sc_hd__tapvpwrvgnd_1_9 VSS VDD sky130_fd_sc_hd__tapvpwrvgnd_1
* cell instance sky130_fd_sc_hd__tapvpwrvgnd_1_10 r0 *1 0,0
Xsky130_fd_sc_hd__tapvpwrvgnd_1_10 VSS VDD sky130_fd_sc_hd__tapvpwrvgnd_1
* cell instance sky130_fd_sc_hd__tapvpwrvgnd_1_11 r0 *1 0,0
Xsky130_fd_sc_hd__tapvpwrvgnd_1_11 VSS VDD sky130_fd_sc_hd__tapvpwrvgnd_1
* cell instance sky130_fd_sc_hd__tapvpwrvgnd_1_12 r0 *1 0,0
Xsky130_fd_sc_hd__tapvpwrvgnd_1_12 VSS VDD sky130_fd_sc_hd__tapvpwrvgnd_1
* cell instance sky130_fd_sc_hd__tapvpwrvgnd_1_13 r0 *1 0,0
Xsky130_fd_sc_hd__tapvpwrvgnd_1_13 VSS VDD sky130_fd_sc_hd__tapvpwrvgnd_1
* cell instance sky130_fd_sc_hd__tapvpwrvgnd_1_14 r0 *1 0,0
Xsky130_fd_sc_hd__tapvpwrvgnd_1_14 VSS VDD sky130_fd_sc_hd__tapvpwrvgnd_1
* cell instance sky130_fd_sc_hd__tapvpwrvgnd_1_15 r0 *1 0,0
Xsky130_fd_sc_hd__tapvpwrvgnd_1_15 VSS VDD sky130_fd_sc_hd__tapvpwrvgnd_1
* cell instance sky130_fd_sc_hd__tapvpwrvgnd_1_16 r0 *1 0,0
Xsky130_fd_sc_hd__tapvpwrvgnd_1_16 VSS VDD sky130_fd_sc_hd__tapvpwrvgnd_1
* cell instance sky130_fd_sc_hd__tapvpwrvgnd_1_17 r0 *1 0,0
Xsky130_fd_sc_hd__tapvpwrvgnd_1_17 VSS VDD sky130_fd_sc_hd__tapvpwrvgnd_1
* cell instance sky130_fd_sc_hd__tapvpwrvgnd_1_18 r0 *1 0,0
Xsky130_fd_sc_hd__tapvpwrvgnd_1_18 VSS VDD sky130_fd_sc_hd__tapvpwrvgnd_1
* cell instance sky130_fd_sc_hd__tapvpwrvgnd_1_19 r0 *1 0,0
Xsky130_fd_sc_hd__tapvpwrvgnd_1_19 VSS VDD sky130_fd_sc_hd__tapvpwrvgnd_1
* cell instance sky130_fd_sc_hd__tapvpwrvgnd_1_20 r0 *1 0,0
Xsky130_fd_sc_hd__tapvpwrvgnd_1_20 VSS VDD sky130_fd_sc_hd__tapvpwrvgnd_1
* cell instance sky130_fd_sc_hd__tapvpwrvgnd_1_21 r0 *1 0,0
Xsky130_fd_sc_hd__tapvpwrvgnd_1_21 VSS VDD sky130_fd_sc_hd__tapvpwrvgnd_1
* cell instance sky130_fd_sc_hd__tapvpwrvgnd_1_22 r0 *1 0,0
Xsky130_fd_sc_hd__tapvpwrvgnd_1_22 VSS VDD sky130_fd_sc_hd__tapvpwrvgnd_1
* cell instance sky130_fd_sc_hd__tapvpwrvgnd_1_23 r0 *1 0,0
Xsky130_fd_sc_hd__tapvpwrvgnd_1_23 VSS VDD sky130_fd_sc_hd__tapvpwrvgnd_1
* cell instance sky130_fd_sc_hd__tapvpwrvgnd_1_24 r0 *1 0,0
Xsky130_fd_sc_hd__tapvpwrvgnd_1_24 VSS VDD sky130_fd_sc_hd__tapvpwrvgnd_1
* cell instance sky130_fd_sc_hd__tapvpwrvgnd_1_25 r0 *1 0,0
Xsky130_fd_sc_hd__tapvpwrvgnd_1_25 VSS VDD sky130_fd_sc_hd__tapvpwrvgnd_1
* cell instance sky130_fd_sc_hd__tapvpwrvgnd_1_26 r0 *1 0,0
Xsky130_fd_sc_hd__tapvpwrvgnd_1_26 VSS VDD sky130_fd_sc_hd__tapvpwrvgnd_1
* cell instance sky130_fd_sc_hd__tapvpwrvgnd_1_27 r0 *1 0,0
Xsky130_fd_sc_hd__tapvpwrvgnd_1_27 VSS VDD sky130_fd_sc_hd__tapvpwrvgnd_1
* cell instance sky130_fd_sc_hd__tapvpwrvgnd_1_28 r0 *1 0,0
Xsky130_fd_sc_hd__tapvpwrvgnd_1_28 VSS VDD sky130_fd_sc_hd__tapvpwrvgnd_1
* cell instance sky130_fd_sc_hd__tapvpwrvgnd_1_29 r0 *1 0,0
Xsky130_fd_sc_hd__tapvpwrvgnd_1_29 VSS VDD sky130_fd_sc_hd__tapvpwrvgnd_1
* cell instance sky130_fd_sc_hd__tapvpwrvgnd_1_30 r0 *1 0,0
Xsky130_fd_sc_hd__tapvpwrvgnd_1_30 VSS VDD sky130_fd_sc_hd__tapvpwrvgnd_1
* cell instance sky130_fd_sc_hd__tapvpwrvgnd_1_31 r0 *1 0,0
Xsky130_fd_sc_hd__tapvpwrvgnd_1_31 VSS VDD sky130_fd_sc_hd__tapvpwrvgnd_1
* cell instance sky130_fd_sc_hd__tapvpwrvgnd_1_32 r0 *1 0,0
Xsky130_fd_sc_hd__tapvpwrvgnd_1_32 VSS VDD sky130_fd_sc_hd__tapvpwrvgnd_1
* cell instance sky130_fd_sc_hd__tapvpwrvgnd_1_33 r0 *1 0,0
Xsky130_fd_sc_hd__tapvpwrvgnd_1_33 VSS VDD sky130_fd_sc_hd__tapvpwrvgnd_1
* cell instance sky130_fd_sc_hd__tapvpwrvgnd_1_34 r0 *1 0,0
Xsky130_fd_sc_hd__tapvpwrvgnd_1_34 VSS VDD sky130_fd_sc_hd__tapvpwrvgnd_1
* cell instance sky130_fd_sc_hd__tapvpwrvgnd_1_35 r0 *1 0,0
Xsky130_fd_sc_hd__tapvpwrvgnd_1_35 VSS VDD sky130_fd_sc_hd__tapvpwrvgnd_1
* cell instance sky130_fd_sc_hd__tapvpwrvgnd_1_36 r0 *1 0,0
Xsky130_fd_sc_hd__tapvpwrvgnd_1_36 VSS VDD sky130_fd_sc_hd__tapvpwrvgnd_1
* cell instance sky130_fd_sc_hd__tapvpwrvgnd_1_37 r0 *1 0,0
Xsky130_fd_sc_hd__tapvpwrvgnd_1_37 VSS VDD sky130_fd_sc_hd__tapvpwrvgnd_1
* cell instance sky130_fd_sc_hd__tapvpwrvgnd_1_38 r0 *1 0,0
Xsky130_fd_sc_hd__tapvpwrvgnd_1_38 VSS VDD sky130_fd_sc_hd__tapvpwrvgnd_1
* cell instance sky130_fd_sc_hd__tapvpwrvgnd_1_39 r0 *1 0,0
Xsky130_fd_sc_hd__tapvpwrvgnd_1_39 VSS VDD sky130_fd_sc_hd__tapvpwrvgnd_1
* cell instance sky130_fd_sc_hd__tapvpwrvgnd_1_40 r0 *1 0,0
Xsky130_fd_sc_hd__tapvpwrvgnd_1_40 VSS VDD sky130_fd_sc_hd__tapvpwrvgnd_1
* cell instance sky130_fd_sc_hd__tapvpwrvgnd_1_41 r0 *1 0,0
Xsky130_fd_sc_hd__tapvpwrvgnd_1_41 VSS VDD sky130_fd_sc_hd__tapvpwrvgnd_1
* cell instance sky130_fd_sc_hd__tapvpwrvgnd_1_42 r0 *1 0,0
Xsky130_fd_sc_hd__tapvpwrvgnd_1_42 VSS VDD sky130_fd_sc_hd__tapvpwrvgnd_1
* cell instance sky130_fd_sc_hd__tapvpwrvgnd_1_43 r0 *1 0,0
Xsky130_fd_sc_hd__tapvpwrvgnd_1_43 VSS VDD sky130_fd_sc_hd__tapvpwrvgnd_1
* cell instance sky130_fd_sc_hd__tapvpwrvgnd_1_44 r0 *1 0,0
Xsky130_fd_sc_hd__tapvpwrvgnd_1_44 VSS VDD sky130_fd_sc_hd__tapvpwrvgnd_1
* cell instance sky130_fd_sc_hd__tapvpwrvgnd_1_45 r0 *1 0,0
Xsky130_fd_sc_hd__tapvpwrvgnd_1_45 VSS VDD sky130_fd_sc_hd__tapvpwrvgnd_1
* cell instance sky130_fd_sc_hd__tapvpwrvgnd_1_46 r0 *1 0,0
Xsky130_fd_sc_hd__tapvpwrvgnd_1_46 VSS VDD sky130_fd_sc_hd__tapvpwrvgnd_1
* cell instance sky130_fd_sc_hd__tapvpwrvgnd_1_47 r0 *1 0,0
Xsky130_fd_sc_hd__tapvpwrvgnd_1_47 VSS VDD sky130_fd_sc_hd__tapvpwrvgnd_1
* cell instance sky130_fd_sc_hd__tapvpwrvgnd_1_48 r0 *1 0,0
Xsky130_fd_sc_hd__tapvpwrvgnd_1_48 VSS VDD sky130_fd_sc_hd__tapvpwrvgnd_1
* cell instance sky130_fd_sc_hd__tapvpwrvgnd_1_49 r0 *1 0,0
Xsky130_fd_sc_hd__tapvpwrvgnd_1_49 VSS VDD sky130_fd_sc_hd__tapvpwrvgnd_1
* cell instance sky130_fd_sc_hd__tapvpwrvgnd_1_50 r0 *1 0,0
Xsky130_fd_sc_hd__tapvpwrvgnd_1_50 VSS VDD sky130_fd_sc_hd__tapvpwrvgnd_1
* cell instance sky130_fd_sc_hd__tapvpwrvgnd_1_51 r0 *1 0,0
Xsky130_fd_sc_hd__tapvpwrvgnd_1_51 VSS VDD sky130_fd_sc_hd__tapvpwrvgnd_1
* cell instance sky130_fd_sc_hd__tapvpwrvgnd_1_52 r0 *1 0,0
Xsky130_fd_sc_hd__tapvpwrvgnd_1_52 VSS VDD sky130_fd_sc_hd__tapvpwrvgnd_1
* cell instance sky130_fd_sc_hd__tapvpwrvgnd_1_53 r0 *1 0,0
Xsky130_fd_sc_hd__tapvpwrvgnd_1_53 VSS VDD sky130_fd_sc_hd__tapvpwrvgnd_1
* cell instance sky130_fd_sc_hd__tapvpwrvgnd_1_54 r0 *1 0,0
Xsky130_fd_sc_hd__tapvpwrvgnd_1_54 VSS VDD sky130_fd_sc_hd__tapvpwrvgnd_1
* cell instance sky130_fd_sc_hd__tapvpwrvgnd_1_55 r0 *1 0,0
Xsky130_fd_sc_hd__tapvpwrvgnd_1_55 VSS VDD sky130_fd_sc_hd__tapvpwrvgnd_1
* cell instance sky130_fd_sc_hd__tapvpwrvgnd_1_56 r0 *1 0,0
Xsky130_fd_sc_hd__tapvpwrvgnd_1_56 VSS VDD sky130_fd_sc_hd__tapvpwrvgnd_1
* cell instance sky130_fd_sc_hd__tapvpwrvgnd_1_57 r0 *1 0,0
Xsky130_fd_sc_hd__tapvpwrvgnd_1_57 VSS VDD sky130_fd_sc_hd__tapvpwrvgnd_1
* cell instance sky130_fd_sc_hd__tapvpwrvgnd_1_58 r0 *1 0,0
Xsky130_fd_sc_hd__tapvpwrvgnd_1_58 VSS VDD sky130_fd_sc_hd__tapvpwrvgnd_1
* cell instance sky130_fd_sc_hd__tapvpwrvgnd_1_59 r0 *1 0,0
Xsky130_fd_sc_hd__tapvpwrvgnd_1_59 VSS VDD sky130_fd_sc_hd__tapvpwrvgnd_1
* cell instance sky130_fd_sc_hd__tapvpwrvgnd_1_60 r0 *1 0,0
Xsky130_fd_sc_hd__tapvpwrvgnd_1_60 VSS VDD sky130_fd_sc_hd__tapvpwrvgnd_1
* cell instance sky130_fd_sc_hd__tapvpwrvgnd_1_61 r0 *1 0,0
Xsky130_fd_sc_hd__tapvpwrvgnd_1_61 VSS VDD sky130_fd_sc_hd__tapvpwrvgnd_1
* cell instance sky130_fd_sc_hd__tapvpwrvgnd_1_62 r0 *1 0,0
Xsky130_fd_sc_hd__tapvpwrvgnd_1_62 VSS VDD sky130_fd_sc_hd__tapvpwrvgnd_1
* cell instance sky130_fd_sc_hd__tapvpwrvgnd_1_63 r0 *1 0,0
Xsky130_fd_sc_hd__tapvpwrvgnd_1_63 VSS VDD sky130_fd_sc_hd__tapvpwrvgnd_1
* cell instance sky130_fd_sc_hd__tapvpwrvgnd_1_64 r0 *1 0,0
Xsky130_fd_sc_hd__tapvpwrvgnd_1_64 VSS VDD sky130_fd_sc_hd__tapvpwrvgnd_1
* cell instance sky130_fd_sc_hd__tapvpwrvgnd_1_65 r0 *1 0,0
Xsky130_fd_sc_hd__tapvpwrvgnd_1_65 VSS VDD sky130_fd_sc_hd__tapvpwrvgnd_1
* cell instance sky130_fd_sc_hd__tapvpwrvgnd_1_66 r0 *1 0,0
Xsky130_fd_sc_hd__tapvpwrvgnd_1_66 VSS VDD sky130_fd_sc_hd__tapvpwrvgnd_1
* cell instance sky130_fd_sc_hd__tapvpwrvgnd_1_67 r0 *1 0,0
Xsky130_fd_sc_hd__tapvpwrvgnd_1_67 VSS VDD sky130_fd_sc_hd__tapvpwrvgnd_1
* cell instance sky130_fd_sc_hd__tapvpwrvgnd_1_68 r0 *1 0,0
Xsky130_fd_sc_hd__tapvpwrvgnd_1_68 VSS VDD sky130_fd_sc_hd__tapvpwrvgnd_1
* cell instance sky130_fd_sc_hd__tapvpwrvgnd_1_69 r0 *1 0,0
Xsky130_fd_sc_hd__tapvpwrvgnd_1_69 VSS VDD sky130_fd_sc_hd__tapvpwrvgnd_1
* cell instance sky130_fd_sc_hd__tapvpwrvgnd_1_70 r0 *1 0,0
Xsky130_fd_sc_hd__tapvpwrvgnd_1_70 VSS VDD sky130_fd_sc_hd__tapvpwrvgnd_1
* cell instance sky130_fd_sc_hd__tapvpwrvgnd_1_71 r0 *1 0,0
Xsky130_fd_sc_hd__tapvpwrvgnd_1_71 VSS VDD sky130_fd_sc_hd__tapvpwrvgnd_1
* cell instance sky130_fd_sc_hd__tapvpwrvgnd_1_72 r0 *1 0,0
Xsky130_fd_sc_hd__tapvpwrvgnd_1_72 VSS VDD sky130_fd_sc_hd__tapvpwrvgnd_1
* cell instance sky130_fd_sc_hd__tapvpwrvgnd_1_73 r0 *1 0,0
Xsky130_fd_sc_hd__tapvpwrvgnd_1_73 VSS VDD sky130_fd_sc_hd__tapvpwrvgnd_1
* cell instance sky130_fd_sc_hd__tapvpwrvgnd_1_74 r0 *1 0,0
Xsky130_fd_sc_hd__tapvpwrvgnd_1_74 VSS VDD sky130_fd_sc_hd__tapvpwrvgnd_1
* cell instance sky130_fd_sc_hd__tapvpwrvgnd_1_75 r0 *1 0,0
Xsky130_fd_sc_hd__tapvpwrvgnd_1_75 VSS VDD sky130_fd_sc_hd__tapvpwrvgnd_1
* cell instance sky130_fd_sc_hd__tapvpwrvgnd_1_76 r0 *1 0,0
Xsky130_fd_sc_hd__tapvpwrvgnd_1_76 VSS VDD sky130_fd_sc_hd__tapvpwrvgnd_1
* cell instance sky130_fd_sc_hd__tapvpwrvgnd_1_77 r0 *1 0,0
Xsky130_fd_sc_hd__tapvpwrvgnd_1_77 VSS VDD sky130_fd_sc_hd__tapvpwrvgnd_1
* cell instance sky130_fd_sc_hd__tapvpwrvgnd_1_78 r0 *1 0,0
Xsky130_fd_sc_hd__tapvpwrvgnd_1_78 VSS VDD sky130_fd_sc_hd__tapvpwrvgnd_1
* cell instance sky130_fd_sc_hd__tapvpwrvgnd_1_79 r0 *1 0,0
Xsky130_fd_sc_hd__tapvpwrvgnd_1_79 VSS VDD sky130_fd_sc_hd__tapvpwrvgnd_1
* cell instance sky130_fd_sc_hd__tapvpwrvgnd_1_80 r0 *1 0,0
Xsky130_fd_sc_hd__tapvpwrvgnd_1_80 VSS VDD sky130_fd_sc_hd__tapvpwrvgnd_1
* cell instance sky130_fd_sc_hd__tapvpwrvgnd_1_81 r0 *1 0,0
Xsky130_fd_sc_hd__tapvpwrvgnd_1_81 VSS VDD sky130_fd_sc_hd__tapvpwrvgnd_1
* cell instance sky130_fd_sc_hd__tapvpwrvgnd_1_82 r0 *1 0,0
Xsky130_fd_sc_hd__tapvpwrvgnd_1_82 VSS VDD sky130_fd_sc_hd__tapvpwrvgnd_1
* cell instance sky130_fd_sc_hd__tapvpwrvgnd_1_83 r0 *1 0,0
Xsky130_fd_sc_hd__tapvpwrvgnd_1_83 VSS VDD sky130_fd_sc_hd__tapvpwrvgnd_1
* cell instance sky130_fd_sc_hd__tapvpwrvgnd_1_84 r0 *1 0,0
Xsky130_fd_sc_hd__tapvpwrvgnd_1_84 VSS VDD sky130_fd_sc_hd__tapvpwrvgnd_1
* cell instance sky130_fd_sc_hd__tapvpwrvgnd_1_85 r0 *1 0,0
Xsky130_fd_sc_hd__tapvpwrvgnd_1_85 VSS VDD sky130_fd_sc_hd__tapvpwrvgnd_1
* cell instance sky130_fd_sc_hd__tapvpwrvgnd_1_86 r0 *1 0,0
Xsky130_fd_sc_hd__tapvpwrvgnd_1_86 VSS VDD sky130_fd_sc_hd__tapvpwrvgnd_1
* cell instance sky130_fd_sc_hd__tapvpwrvgnd_1_87 r0 *1 0,0
Xsky130_fd_sc_hd__tapvpwrvgnd_1_87 VSS VDD sky130_fd_sc_hd__tapvpwrvgnd_1
* cell instance sky130_fd_sc_hd__tapvpwrvgnd_1_88 r0 *1 0,0
Xsky130_fd_sc_hd__tapvpwrvgnd_1_88 VSS VDD sky130_fd_sc_hd__tapvpwrvgnd_1
* cell instance sky130_fd_sc_hd__tapvpwrvgnd_1_89 r0 *1 0,0
Xsky130_fd_sc_hd__tapvpwrvgnd_1_89 VSS VDD sky130_fd_sc_hd__tapvpwrvgnd_1
* cell instance sky130_fd_sc_hd__tapvpwrvgnd_1_90 r0 *1 0,0
Xsky130_fd_sc_hd__tapvpwrvgnd_1_90 VSS VDD sky130_fd_sc_hd__tapvpwrvgnd_1
* cell instance sky130_fd_sc_hd__tapvpwrvgnd_1_91 r0 *1 0,0
Xsky130_fd_sc_hd__tapvpwrvgnd_1_91 VSS VDD sky130_fd_sc_hd__tapvpwrvgnd_1
* cell instance sky130_fd_sc_hd__tapvpwrvgnd_1_92 r0 *1 0,0
Xsky130_fd_sc_hd__tapvpwrvgnd_1_92 VSS VDD sky130_fd_sc_hd__tapvpwrvgnd_1
* cell instance sky130_fd_sc_hd__tapvpwrvgnd_1_93 r0 *1 0,0
Xsky130_fd_sc_hd__tapvpwrvgnd_1_93 VSS VDD sky130_fd_sc_hd__tapvpwrvgnd_1
* cell instance sky130_fd_sc_hd__tapvpwrvgnd_1_94 r0 *1 0,0
Xsky130_fd_sc_hd__tapvpwrvgnd_1_94 VSS VDD sky130_fd_sc_hd__tapvpwrvgnd_1
* cell instance sky130_fd_sc_hd__tapvpwrvgnd_1_95 r0 *1 0,0
Xsky130_fd_sc_hd__tapvpwrvgnd_1_95 VSS VDD sky130_fd_sc_hd__tapvpwrvgnd_1
* cell instance sky130_fd_sc_hd__tapvpwrvgnd_1_96 r0 *1 0,0
Xsky130_fd_sc_hd__tapvpwrvgnd_1_96 VSS VDD sky130_fd_sc_hd__tapvpwrvgnd_1
* cell instance sky130_fd_sc_hd__tapvpwrvgnd_1_97 r0 *1 0,0
Xsky130_fd_sc_hd__tapvpwrvgnd_1_97 VSS VDD sky130_fd_sc_hd__tapvpwrvgnd_1
* cell instance sky130_fd_sc_hd__tapvpwrvgnd_1_98 r0 *1 0,0
Xsky130_fd_sc_hd__tapvpwrvgnd_1_98 VSS VDD sky130_fd_sc_hd__tapvpwrvgnd_1
* cell instance sky130_fd_sc_hd__tapvpwrvgnd_1_99 r0 *1 0,0
Xsky130_fd_sc_hd__tapvpwrvgnd_1_99 VSS VDD sky130_fd_sc_hd__tapvpwrvgnd_1
* cell instance sky130_fd_sc_hd__tapvpwrvgnd_1_100 r0 *1 0,0
Xsky130_fd_sc_hd__tapvpwrvgnd_1_100 VSS VDD sky130_fd_sc_hd__tapvpwrvgnd_1
* cell instance sky130_fd_sc_hd__tapvpwrvgnd_1_101 r0 *1 0,0
Xsky130_fd_sc_hd__tapvpwrvgnd_1_101 VSS VDD sky130_fd_sc_hd__tapvpwrvgnd_1
* cell instance sky130_fd_sc_hd__tapvpwrvgnd_1_102 r0 *1 0,0
Xsky130_fd_sc_hd__tapvpwrvgnd_1_102 VSS VDD sky130_fd_sc_hd__tapvpwrvgnd_1
* cell instance sky130_fd_sc_hd__tapvpwrvgnd_1_103 r0 *1 0,0
Xsky130_fd_sc_hd__tapvpwrvgnd_1_103 VSS VDD sky130_fd_sc_hd__tapvpwrvgnd_1
* cell instance sky130_fd_sc_hd__tapvpwrvgnd_1_104 r0 *1 0,0
Xsky130_fd_sc_hd__tapvpwrvgnd_1_104 VSS VDD sky130_fd_sc_hd__tapvpwrvgnd_1
* cell instance sky130_fd_sc_hd__tapvpwrvgnd_1_105 r0 *1 0,0
Xsky130_fd_sc_hd__tapvpwrvgnd_1_105 VSS VDD sky130_fd_sc_hd__tapvpwrvgnd_1
* cell instance sky130_fd_sc_hd__tapvpwrvgnd_1_106 r0 *1 0,0
Xsky130_fd_sc_hd__tapvpwrvgnd_1_106 VSS VDD sky130_fd_sc_hd__tapvpwrvgnd_1
* cell instance sky130_fd_sc_hd__tapvpwrvgnd_1_107 r0 *1 0,0
Xsky130_fd_sc_hd__tapvpwrvgnd_1_107 VSS VDD sky130_fd_sc_hd__tapvpwrvgnd_1
* cell instance sky130_fd_sc_hd__tapvpwrvgnd_1_108 r0 *1 0,0
Xsky130_fd_sc_hd__tapvpwrvgnd_1_108 VSS VDD sky130_fd_sc_hd__tapvpwrvgnd_1
* cell instance sky130_fd_sc_hd__tapvpwrvgnd_1_109 r0 *1 0,0
Xsky130_fd_sc_hd__tapvpwrvgnd_1_109 VSS VDD sky130_fd_sc_hd__tapvpwrvgnd_1
* cell instance sky130_fd_sc_hd__tapvpwrvgnd_1_110 r0 *1 0,0
Xsky130_fd_sc_hd__tapvpwrvgnd_1_110 VSS VDD sky130_fd_sc_hd__tapvpwrvgnd_1
* cell instance sky130_fd_sc_hd__tapvpwrvgnd_1_111 r0 *1 0,0
Xsky130_fd_sc_hd__tapvpwrvgnd_1_111 VSS VDD sky130_fd_sc_hd__tapvpwrvgnd_1
* cell instance sky130_fd_sc_hd__tapvpwrvgnd_1_112 r0 *1 0,0
Xsky130_fd_sc_hd__tapvpwrvgnd_1_112 VSS VDD sky130_fd_sc_hd__tapvpwrvgnd_1
* cell instance sky130_fd_sc_hd__tapvpwrvgnd_1_113 r0 *1 0,0
Xsky130_fd_sc_hd__tapvpwrvgnd_1_113 VSS VDD sky130_fd_sc_hd__tapvpwrvgnd_1
* cell instance sky130_fd_sc_hd__tapvpwrvgnd_1_114 r0 *1 0,0
Xsky130_fd_sc_hd__tapvpwrvgnd_1_114 VSS VDD sky130_fd_sc_hd__tapvpwrvgnd_1
* cell instance sky130_fd_sc_hd__tapvpwrvgnd_1_115 r0 *1 0,0
Xsky130_fd_sc_hd__tapvpwrvgnd_1_115 VSS VDD sky130_fd_sc_hd__tapvpwrvgnd_1
* cell instance sky130_fd_sc_hd__tapvpwrvgnd_1_116 r0 *1 0,0
Xsky130_fd_sc_hd__tapvpwrvgnd_1_116 VSS VDD sky130_fd_sc_hd__tapvpwrvgnd_1
* cell instance sky130_fd_sc_hd__tapvpwrvgnd_1_117 r0 *1 0,0
Xsky130_fd_sc_hd__tapvpwrvgnd_1_117 VSS VDD sky130_fd_sc_hd__tapvpwrvgnd_1
* cell instance sky130_fd_sc_hd__tapvpwrvgnd_1_118 r0 *1 0,0
Xsky130_fd_sc_hd__tapvpwrvgnd_1_118 VSS VDD sky130_fd_sc_hd__tapvpwrvgnd_1
* cell instance sky130_fd_sc_hd__tapvpwrvgnd_1_119 r0 *1 0,0
Xsky130_fd_sc_hd__tapvpwrvgnd_1_119 VSS VDD sky130_fd_sc_hd__tapvpwrvgnd_1
* cell instance sky130_fd_sc_hd__tapvpwrvgnd_1_120 r0 *1 0,0
Xsky130_fd_sc_hd__tapvpwrvgnd_1_120 VSS VDD sky130_fd_sc_hd__tapvpwrvgnd_1
* cell instance sky130_fd_sc_hd__tapvpwrvgnd_1_121 r0 *1 0,0
Xsky130_fd_sc_hd__tapvpwrvgnd_1_121 VSS VDD sky130_fd_sc_hd__tapvpwrvgnd_1
* cell instance sky130_fd_sc_hd__tapvpwrvgnd_1_122 r0 *1 0,0
Xsky130_fd_sc_hd__tapvpwrvgnd_1_122 VSS VDD sky130_fd_sc_hd__tapvpwrvgnd_1
* cell instance sky130_fd_sc_hd__tapvpwrvgnd_1_123 r0 *1 0,0
Xsky130_fd_sc_hd__tapvpwrvgnd_1_123 VSS VDD sky130_fd_sc_hd__tapvpwrvgnd_1
* cell instance sky130_fd_sc_hd__tapvpwrvgnd_1_124 r0 *1 0,0
Xsky130_fd_sc_hd__tapvpwrvgnd_1_124 VSS VDD sky130_fd_sc_hd__tapvpwrvgnd_1
* cell instance sky130_fd_sc_hd__tapvpwrvgnd_1_125 r0 *1 0,0
Xsky130_fd_sc_hd__tapvpwrvgnd_1_125 VSS VDD sky130_fd_sc_hd__tapvpwrvgnd_1
* cell instance sky130_fd_sc_hd__tapvpwrvgnd_1_126 r0 *1 0,0
Xsky130_fd_sc_hd__tapvpwrvgnd_1_126 VSS VDD sky130_fd_sc_hd__tapvpwrvgnd_1
* cell instance sky130_fd_sc_hd__tapvpwrvgnd_1_127 r0 *1 0,0
Xsky130_fd_sc_hd__tapvpwrvgnd_1_127 VSS VDD sky130_fd_sc_hd__tapvpwrvgnd_1
* cell instance sky130_fd_sc_hd__tapvpwrvgnd_1_128 r0 *1 0,0
Xsky130_fd_sc_hd__tapvpwrvgnd_1_128 VSS VDD sky130_fd_sc_hd__tapvpwrvgnd_1
* cell instance sky130_fd_sc_hd__tapvpwrvgnd_1_129 r0 *1 0,0
Xsky130_fd_sc_hd__tapvpwrvgnd_1_129 VSS VDD sky130_fd_sc_hd__tapvpwrvgnd_1
* cell instance sky130_fd_sc_hd__tapvpwrvgnd_1_130 r0 *1 0,0
Xsky130_fd_sc_hd__tapvpwrvgnd_1_130 VSS VDD sky130_fd_sc_hd__tapvpwrvgnd_1
* cell instance sky130_fd_sc_hd__tapvpwrvgnd_1_131 r0 *1 0,0
Xsky130_fd_sc_hd__tapvpwrvgnd_1_131 VSS VDD sky130_fd_sc_hd__tapvpwrvgnd_1
* cell instance sky130_fd_sc_hd__tapvpwrvgnd_1_132 r0 *1 0,0
Xsky130_fd_sc_hd__tapvpwrvgnd_1_132 VSS VDD sky130_fd_sc_hd__tapvpwrvgnd_1
* cell instance sky130_fd_sc_hd__tapvpwrvgnd_1_133 r0 *1 0,0
Xsky130_fd_sc_hd__tapvpwrvgnd_1_133 VSS VDD sky130_fd_sc_hd__tapvpwrvgnd_1
* cell instance sky130_fd_sc_hd__tapvpwrvgnd_1_134 r0 *1 0,0
Xsky130_fd_sc_hd__tapvpwrvgnd_1_134 VSS VDD sky130_fd_sc_hd__tapvpwrvgnd_1
* cell instance sky130_fd_sc_hd__tapvpwrvgnd_1_135 r0 *1 0,0
Xsky130_fd_sc_hd__tapvpwrvgnd_1_135 VSS VDD sky130_fd_sc_hd__tapvpwrvgnd_1
* cell instance sky130_fd_sc_hd__tapvpwrvgnd_1_136 r0 *1 0,0
Xsky130_fd_sc_hd__tapvpwrvgnd_1_136 VSS VDD sky130_fd_sc_hd__tapvpwrvgnd_1
* cell instance sky130_fd_sc_hd__tapvpwrvgnd_1_137 r0 *1 0,0
Xsky130_fd_sc_hd__tapvpwrvgnd_1_137 VSS VDD sky130_fd_sc_hd__tapvpwrvgnd_1
* cell instance sky130_fd_sc_hd__tapvpwrvgnd_1_138 r0 *1 0,0
Xsky130_fd_sc_hd__tapvpwrvgnd_1_138 VSS VDD sky130_fd_sc_hd__tapvpwrvgnd_1
* cell instance sky130_fd_sc_hd__tapvpwrvgnd_1_139 r0 *1 0,0
Xsky130_fd_sc_hd__tapvpwrvgnd_1_139 VSS VDD sky130_fd_sc_hd__tapvpwrvgnd_1
* cell instance sky130_fd_sc_hd__tapvpwrvgnd_1_140 r0 *1 0,0
Xsky130_fd_sc_hd__tapvpwrvgnd_1_140 VSS VDD sky130_fd_sc_hd__tapvpwrvgnd_1
* cell instance sky130_fd_sc_hd__tapvpwrvgnd_1_141 r0 *1 0,0
Xsky130_fd_sc_hd__tapvpwrvgnd_1_141 VSS VDD sky130_fd_sc_hd__tapvpwrvgnd_1
* cell instance sky130_fd_sc_hd__tapvpwrvgnd_1_142 r0 *1 0,0
Xsky130_fd_sc_hd__tapvpwrvgnd_1_142 VSS VDD sky130_fd_sc_hd__tapvpwrvgnd_1
* cell instance sky130_fd_sc_hd__tapvpwrvgnd_1_143 r0 *1 0,0
Xsky130_fd_sc_hd__tapvpwrvgnd_1_143 VSS VDD sky130_fd_sc_hd__tapvpwrvgnd_1
* cell instance sky130_fd_sc_hd__tapvpwrvgnd_1_144 r0 *1 0,0
Xsky130_fd_sc_hd__tapvpwrvgnd_1_144 VSS VDD sky130_fd_sc_hd__tapvpwrvgnd_1
* cell instance sky130_fd_sc_hd__tapvpwrvgnd_1_145 r0 *1 0,0
Xsky130_fd_sc_hd__tapvpwrvgnd_1_145 VSS VDD sky130_fd_sc_hd__tapvpwrvgnd_1
* cell instance sky130_fd_sc_hd__tapvpwrvgnd_1_146 r0 *1 0,0
Xsky130_fd_sc_hd__tapvpwrvgnd_1_146 VSS VDD sky130_fd_sc_hd__tapvpwrvgnd_1
* cell instance sky130_fd_sc_hd__tapvpwrvgnd_1_147 r0 *1 0,0
Xsky130_fd_sc_hd__tapvpwrvgnd_1_147 VSS VDD sky130_fd_sc_hd__tapvpwrvgnd_1
* cell instance sky130_fd_sc_hd__tapvpwrvgnd_1_148 r0 *1 0,0
Xsky130_fd_sc_hd__tapvpwrvgnd_1_148 VSS VDD sky130_fd_sc_hd__tapvpwrvgnd_1
* cell instance sky130_fd_sc_hd__tapvpwrvgnd_1_149 r0 *1 0,0
Xsky130_fd_sc_hd__tapvpwrvgnd_1_149 VSS VDD sky130_fd_sc_hd__tapvpwrvgnd_1
* cell instance sky130_fd_sc_hd__tapvpwrvgnd_1_150 r0 *1 0,0
Xsky130_fd_sc_hd__tapvpwrvgnd_1_150 VSS VDD sky130_fd_sc_hd__tapvpwrvgnd_1
* cell instance sky130_fd_sc_hd__tapvpwrvgnd_1_151 r0 *1 0,0
Xsky130_fd_sc_hd__tapvpwrvgnd_1_151 VSS VDD sky130_fd_sc_hd__tapvpwrvgnd_1
* cell instance sky130_fd_sc_hd__tapvpwrvgnd_1_152 r0 *1 0,0
Xsky130_fd_sc_hd__tapvpwrvgnd_1_152 VSS VDD sky130_fd_sc_hd__tapvpwrvgnd_1
* cell instance sky130_fd_sc_hd__tapvpwrvgnd_1_153 r0 *1 0,0
Xsky130_fd_sc_hd__tapvpwrvgnd_1_153 VSS VDD sky130_fd_sc_hd__tapvpwrvgnd_1
* cell instance sky130_fd_sc_hd__tapvpwrvgnd_1_154 r0 *1 0,0
Xsky130_fd_sc_hd__tapvpwrvgnd_1_154 VSS VDD sky130_fd_sc_hd__tapvpwrvgnd_1
* cell instance sky130_fd_sc_hd__tapvpwrvgnd_1_155 r0 *1 0,0
Xsky130_fd_sc_hd__tapvpwrvgnd_1_155 VSS VDD sky130_fd_sc_hd__tapvpwrvgnd_1
* cell instance sky130_fd_sc_hd__tapvpwrvgnd_1_156 r0 *1 0,0
Xsky130_fd_sc_hd__tapvpwrvgnd_1_156 VSS VDD sky130_fd_sc_hd__tapvpwrvgnd_1
* cell instance sky130_fd_sc_hd__tapvpwrvgnd_1_157 r0 *1 0,0
Xsky130_fd_sc_hd__tapvpwrvgnd_1_157 VSS VDD sky130_fd_sc_hd__tapvpwrvgnd_1
* cell instance sky130_fd_sc_hd__tapvpwrvgnd_1_158 r0 *1 0,0
Xsky130_fd_sc_hd__tapvpwrvgnd_1_158 VSS VDD sky130_fd_sc_hd__tapvpwrvgnd_1
* cell instance sky130_fd_sc_hd__tapvpwrvgnd_1_159 r0 *1 0,0
Xsky130_fd_sc_hd__tapvpwrvgnd_1_159 VSS VDD sky130_fd_sc_hd__tapvpwrvgnd_1
* cell instance sky130_fd_sc_hd__tapvpwrvgnd_1_160 r0 *1 0,0
Xsky130_fd_sc_hd__tapvpwrvgnd_1_160 VSS VDD sky130_fd_sc_hd__tapvpwrvgnd_1
* cell instance sky130_fd_sc_hd__tapvpwrvgnd_1_161 r0 *1 0,0
Xsky130_fd_sc_hd__tapvpwrvgnd_1_161 VSS VDD sky130_fd_sc_hd__tapvpwrvgnd_1
* cell instance sky130_fd_sc_hd__tapvpwrvgnd_1_162 r0 *1 0,0
Xsky130_fd_sc_hd__tapvpwrvgnd_1_162 VSS VDD sky130_fd_sc_hd__tapvpwrvgnd_1
* cell instance sky130_fd_sc_hd__tapvpwrvgnd_1_163 r0 *1 0,0
Xsky130_fd_sc_hd__tapvpwrvgnd_1_163 VSS VDD sky130_fd_sc_hd__tapvpwrvgnd_1
* cell instance sky130_fd_sc_hd__tapvpwrvgnd_1_164 r0 *1 0,0
Xsky130_fd_sc_hd__tapvpwrvgnd_1_164 VSS VDD sky130_fd_sc_hd__tapvpwrvgnd_1
* cell instance sky130_fd_sc_hd__tapvpwrvgnd_1_165 r0 *1 0,0
Xsky130_fd_sc_hd__tapvpwrvgnd_1_165 VSS VDD sky130_fd_sc_hd__tapvpwrvgnd_1
* cell instance sky130_fd_sc_hd__tapvpwrvgnd_1_166 r0 *1 0,0
Xsky130_fd_sc_hd__tapvpwrvgnd_1_166 VSS VDD sky130_fd_sc_hd__tapvpwrvgnd_1
* cell instance sky130_fd_sc_hd__tapvpwrvgnd_1_167 r0 *1 0,0
Xsky130_fd_sc_hd__tapvpwrvgnd_1_167 VSS VDD sky130_fd_sc_hd__tapvpwrvgnd_1
* cell instance sky130_fd_sc_hd__tapvpwrvgnd_1_168 r0 *1 0,0
Xsky130_fd_sc_hd__tapvpwrvgnd_1_168 VSS VDD sky130_fd_sc_hd__tapvpwrvgnd_1
* cell instance sky130_fd_sc_hd__tapvpwrvgnd_1_169 r0 *1 0,0
Xsky130_fd_sc_hd__tapvpwrvgnd_1_169 VSS VDD sky130_fd_sc_hd__tapvpwrvgnd_1
* cell instance sky130_fd_sc_hd__tapvpwrvgnd_1_170 r0 *1 0,0
Xsky130_fd_sc_hd__tapvpwrvgnd_1_170 VSS VDD sky130_fd_sc_hd__tapvpwrvgnd_1
* cell instance sky130_fd_sc_hd__tapvpwrvgnd_1_171 r0 *1 0,0
Xsky130_fd_sc_hd__tapvpwrvgnd_1_171 VSS VDD sky130_fd_sc_hd__tapvpwrvgnd_1
* cell instance sky130_fd_sc_hd__tapvpwrvgnd_1_172 r0 *1 0,0
Xsky130_fd_sc_hd__tapvpwrvgnd_1_172 VSS VDD sky130_fd_sc_hd__tapvpwrvgnd_1
* cell instance sky130_fd_sc_hd__tapvpwrvgnd_1_173 r0 *1 0,0
Xsky130_fd_sc_hd__tapvpwrvgnd_1_173 VSS VDD sky130_fd_sc_hd__tapvpwrvgnd_1
* cell instance sky130_fd_sc_hd__tapvpwrvgnd_1_174 r0 *1 0,0
Xsky130_fd_sc_hd__tapvpwrvgnd_1_174 VSS VDD sky130_fd_sc_hd__tapvpwrvgnd_1
* cell instance sky130_fd_sc_hd__tapvpwrvgnd_1_175 r0 *1 0,0
Xsky130_fd_sc_hd__tapvpwrvgnd_1_175 VSS VDD sky130_fd_sc_hd__tapvpwrvgnd_1
* cell instance sky130_fd_sc_hd__tapvpwrvgnd_1_176 r0 *1 0,0
Xsky130_fd_sc_hd__tapvpwrvgnd_1_176 VSS VDD sky130_fd_sc_hd__tapvpwrvgnd_1
* cell instance sky130_fd_sc_hd__tapvpwrvgnd_1_177 r0 *1 0,0
Xsky130_fd_sc_hd__tapvpwrvgnd_1_177 VSS VDD sky130_fd_sc_hd__tapvpwrvgnd_1
* cell instance sky130_fd_sc_hd__tapvpwrvgnd_1_178 r0 *1 0,0
Xsky130_fd_sc_hd__tapvpwrvgnd_1_178 VSS VDD sky130_fd_sc_hd__tapvpwrvgnd_1
* cell instance sky130_fd_sc_hd__tapvpwrvgnd_1_179 r0 *1 0,0
Xsky130_fd_sc_hd__tapvpwrvgnd_1_179 VSS VDD sky130_fd_sc_hd__tapvpwrvgnd_1
* cell instance sky130_fd_sc_hd__tapvpwrvgnd_1_180 r0 *1 0,0
Xsky130_fd_sc_hd__tapvpwrvgnd_1_180 VSS VDD sky130_fd_sc_hd__tapvpwrvgnd_1
* cell instance sky130_fd_sc_hd__tapvpwrvgnd_1_181 r0 *1 0,0
Xsky130_fd_sc_hd__tapvpwrvgnd_1_181 VSS VDD sky130_fd_sc_hd__tapvpwrvgnd_1
* cell instance sky130_fd_sc_hd__tapvpwrvgnd_1_182 r0 *1 0,0
Xsky130_fd_sc_hd__tapvpwrvgnd_1_182 VSS VDD sky130_fd_sc_hd__tapvpwrvgnd_1
* cell instance sky130_fd_sc_hd__tapvpwrvgnd_1_183 r0 *1 0,0
Xsky130_fd_sc_hd__tapvpwrvgnd_1_183 VSS VDD sky130_fd_sc_hd__tapvpwrvgnd_1
* cell instance sky130_fd_sc_hd__tapvpwrvgnd_1_184 r0 *1 0,0
Xsky130_fd_sc_hd__tapvpwrvgnd_1_184 VSS VDD sky130_fd_sc_hd__tapvpwrvgnd_1
* cell instance sky130_fd_sc_hd__tapvpwrvgnd_1_185 r0 *1 0,0
Xsky130_fd_sc_hd__tapvpwrvgnd_1_185 VSS VDD sky130_fd_sc_hd__tapvpwrvgnd_1
* cell instance sky130_fd_sc_hd__tapvpwrvgnd_1_186 r0 *1 0,0
Xsky130_fd_sc_hd__tapvpwrvgnd_1_186 VSS VDD sky130_fd_sc_hd__tapvpwrvgnd_1
* cell instance sky130_fd_sc_hd__tapvpwrvgnd_1_187 r0 *1 0,0
Xsky130_fd_sc_hd__tapvpwrvgnd_1_187 VSS VDD sky130_fd_sc_hd__tapvpwrvgnd_1
* cell instance sky130_fd_sc_hd__tapvpwrvgnd_1_188 r0 *1 0,0
Xsky130_fd_sc_hd__tapvpwrvgnd_1_188 VSS VDD sky130_fd_sc_hd__tapvpwrvgnd_1
* cell instance sky130_fd_sc_hd__tapvpwrvgnd_1_189 r0 *1 0,0
Xsky130_fd_sc_hd__tapvpwrvgnd_1_189 VSS VDD sky130_fd_sc_hd__tapvpwrvgnd_1
* cell instance sky130_fd_sc_hd__tapvpwrvgnd_1_190 r0 *1 0,0
Xsky130_fd_sc_hd__tapvpwrvgnd_1_190 VSS VDD sky130_fd_sc_hd__tapvpwrvgnd_1
* cell instance sky130_fd_sc_hd__tapvpwrvgnd_1_191 r0 *1 0,0
Xsky130_fd_sc_hd__tapvpwrvgnd_1_191 VSS VDD sky130_fd_sc_hd__tapvpwrvgnd_1
* cell instance sky130_fd_sc_hd__tapvpwrvgnd_1_192 r0 *1 0,0
Xsky130_fd_sc_hd__tapvpwrvgnd_1_192 VSS VDD sky130_fd_sc_hd__tapvpwrvgnd_1
* cell instance sky130_fd_sc_hd__tapvpwrvgnd_1_193 r0 *1 0,0
Xsky130_fd_sc_hd__tapvpwrvgnd_1_193 VSS VDD sky130_fd_sc_hd__tapvpwrvgnd_1
* cell instance sky130_fd_sc_hd__tapvpwrvgnd_1_194 r0 *1 0,0
Xsky130_fd_sc_hd__tapvpwrvgnd_1_194 VSS VDD sky130_fd_sc_hd__tapvpwrvgnd_1
* cell instance sky130_fd_sc_hd__tapvpwrvgnd_1_195 r0 *1 0,0
Xsky130_fd_sc_hd__tapvpwrvgnd_1_195 VSS VDD sky130_fd_sc_hd__tapvpwrvgnd_1
* cell instance sky130_fd_sc_hd__tapvpwrvgnd_1_196 r0 *1 0,0
Xsky130_fd_sc_hd__tapvpwrvgnd_1_196 VSS VDD sky130_fd_sc_hd__tapvpwrvgnd_1
* cell instance sky130_fd_sc_hd__tapvpwrvgnd_1_197 r0 *1 0,0
Xsky130_fd_sc_hd__tapvpwrvgnd_1_197 VSS VDD sky130_fd_sc_hd__tapvpwrvgnd_1
* cell instance sky130_fd_sc_hd__tapvpwrvgnd_1_198 r0 *1 0,0
Xsky130_fd_sc_hd__tapvpwrvgnd_1_198 VSS VDD sky130_fd_sc_hd__tapvpwrvgnd_1
* cell instance sky130_fd_sc_hd__tapvpwrvgnd_1_199 r0 *1 0,0
Xsky130_fd_sc_hd__tapvpwrvgnd_1_199 VSS VDD sky130_fd_sc_hd__tapvpwrvgnd_1
* cell instance sky130_fd_sc_hd__tapvpwrvgnd_1_200 r0 *1 0,0
Xsky130_fd_sc_hd__tapvpwrvgnd_1_200 VSS VDD sky130_fd_sc_hd__tapvpwrvgnd_1
* cell instance sky130_fd_sc_hd__tapvpwrvgnd_1_201 r0 *1 0,0
Xsky130_fd_sc_hd__tapvpwrvgnd_1_201 VSS VDD sky130_fd_sc_hd__tapvpwrvgnd_1
* cell instance sky130_fd_sc_hd__tapvpwrvgnd_1_202 r0 *1 0,0
Xsky130_fd_sc_hd__tapvpwrvgnd_1_202 VSS VDD sky130_fd_sc_hd__tapvpwrvgnd_1
* cell instance sky130_fd_sc_hd__tapvpwrvgnd_1_203 r0 *1 0,0
Xsky130_fd_sc_hd__tapvpwrvgnd_1_203 VSS VDD sky130_fd_sc_hd__tapvpwrvgnd_1
* cell instance sky130_fd_sc_hd__tapvpwrvgnd_1_204 r0 *1 0,0
Xsky130_fd_sc_hd__tapvpwrvgnd_1_204 VSS VDD sky130_fd_sc_hd__tapvpwrvgnd_1
* cell instance sky130_fd_sc_hd__tapvpwrvgnd_1_205 r0 *1 0,0
Xsky130_fd_sc_hd__tapvpwrvgnd_1_205 VSS VDD sky130_fd_sc_hd__tapvpwrvgnd_1
* cell instance sky130_fd_sc_hd__tapvpwrvgnd_1_206 r0 *1 0,0
Xsky130_fd_sc_hd__tapvpwrvgnd_1_206 VSS VDD sky130_fd_sc_hd__tapvpwrvgnd_1
* cell instance sky130_fd_sc_hd__tapvpwrvgnd_1_207 r0 *1 0,0
Xsky130_fd_sc_hd__tapvpwrvgnd_1_207 VSS VDD sky130_fd_sc_hd__tapvpwrvgnd_1
* cell instance sky130_fd_sc_hd__tapvpwrvgnd_1_208 r0 *1 0,0
Xsky130_fd_sc_hd__tapvpwrvgnd_1_208 VSS VDD sky130_fd_sc_hd__tapvpwrvgnd_1
* cell instance sky130_fd_sc_hd__tapvpwrvgnd_1_209 r0 *1 0,0
Xsky130_fd_sc_hd__tapvpwrvgnd_1_209 VSS VDD sky130_fd_sc_hd__tapvpwrvgnd_1
* cell instance sky130_fd_sc_hd__tapvpwrvgnd_1_210 r0 *1 0,0
Xsky130_fd_sc_hd__tapvpwrvgnd_1_210 VSS VDD sky130_fd_sc_hd__tapvpwrvgnd_1
* cell instance sky130_fd_sc_hd__tapvpwrvgnd_1_211 r0 *1 0,0
Xsky130_fd_sc_hd__tapvpwrvgnd_1_211 VSS VDD sky130_fd_sc_hd__tapvpwrvgnd_1
* cell instance sky130_fd_sc_hd__tapvpwrvgnd_1_212 r0 *1 0,0
Xsky130_fd_sc_hd__tapvpwrvgnd_1_212 VSS VDD sky130_fd_sc_hd__tapvpwrvgnd_1
* cell instance sky130_fd_sc_hd__tapvpwrvgnd_1_213 r0 *1 0,0
Xsky130_fd_sc_hd__tapvpwrvgnd_1_213 VSS VDD sky130_fd_sc_hd__tapvpwrvgnd_1
* cell instance sky130_fd_sc_hd__tapvpwrvgnd_1_214 r0 *1 0,0
Xsky130_fd_sc_hd__tapvpwrvgnd_1_214 VSS VDD sky130_fd_sc_hd__tapvpwrvgnd_1
* cell instance sky130_fd_sc_hd__tapvpwrvgnd_1_215 r0 *1 0,0
Xsky130_fd_sc_hd__tapvpwrvgnd_1_215 VSS VDD sky130_fd_sc_hd__tapvpwrvgnd_1
* cell instance sky130_fd_sc_hd__tapvpwrvgnd_1_216 r0 *1 0,0
Xsky130_fd_sc_hd__tapvpwrvgnd_1_216 VSS VDD sky130_fd_sc_hd__tapvpwrvgnd_1
* cell instance sky130_fd_sc_hd__tapvpwrvgnd_1_217 r0 *1 0,0
Xsky130_fd_sc_hd__tapvpwrvgnd_1_217 VSS VDD sky130_fd_sc_hd__tapvpwrvgnd_1
* cell instance sky130_fd_sc_hd__tapvpwrvgnd_1_218 r0 *1 0,0
Xsky130_fd_sc_hd__tapvpwrvgnd_1_218 VSS VDD sky130_fd_sc_hd__tapvpwrvgnd_1
* cell instance sky130_fd_sc_hd__tapvpwrvgnd_1_219 r0 *1 0,0
Xsky130_fd_sc_hd__tapvpwrvgnd_1_219 VSS VDD sky130_fd_sc_hd__tapvpwrvgnd_1
* cell instance sky130_fd_sc_hd__tapvpwrvgnd_1_220 r0 *1 0,0
Xsky130_fd_sc_hd__tapvpwrvgnd_1_220 VSS VDD sky130_fd_sc_hd__tapvpwrvgnd_1
* cell instance sky130_fd_sc_hd__tapvpwrvgnd_1_221 r0 *1 0,0
Xsky130_fd_sc_hd__tapvpwrvgnd_1_221 VSS VDD sky130_fd_sc_hd__tapvpwrvgnd_1
* cell instance sky130_fd_sc_hd__tapvpwrvgnd_1_222 r0 *1 0,0
Xsky130_fd_sc_hd__tapvpwrvgnd_1_222 VSS VDD sky130_fd_sc_hd__tapvpwrvgnd_1
* cell instance sky130_fd_sc_hd__tapvpwrvgnd_1_223 r0 *1 0,0
Xsky130_fd_sc_hd__tapvpwrvgnd_1_223 VSS VDD sky130_fd_sc_hd__tapvpwrvgnd_1
* cell instance sky130_fd_sc_hd__tapvpwrvgnd_1_224 r0 *1 0,0
Xsky130_fd_sc_hd__tapvpwrvgnd_1_224 VSS VDD sky130_fd_sc_hd__tapvpwrvgnd_1
* cell instance sky130_fd_sc_hd__tapvpwrvgnd_1_225 r0 *1 0,0
Xsky130_fd_sc_hd__tapvpwrvgnd_1_225 VSS VDD sky130_fd_sc_hd__tapvpwrvgnd_1
* cell instance sky130_fd_sc_hd__tapvpwrvgnd_1_226 r0 *1 0,0
Xsky130_fd_sc_hd__tapvpwrvgnd_1_226 VSS VDD sky130_fd_sc_hd__tapvpwrvgnd_1
* cell instance sky130_fd_sc_hd__tapvpwrvgnd_1_227 r0 *1 0,0
Xsky130_fd_sc_hd__tapvpwrvgnd_1_227 VSS VDD sky130_fd_sc_hd__tapvpwrvgnd_1
* cell instance sky130_fd_sc_hd__tapvpwrvgnd_1_228 r0 *1 0,0
Xsky130_fd_sc_hd__tapvpwrvgnd_1_228 VSS VDD sky130_fd_sc_hd__tapvpwrvgnd_1
* cell instance sky130_fd_sc_hd__tapvpwrvgnd_1_229 r0 *1 0,0
Xsky130_fd_sc_hd__tapvpwrvgnd_1_229 VSS VDD sky130_fd_sc_hd__tapvpwrvgnd_1
* cell instance sky130_fd_sc_hd__tapvpwrvgnd_1_230 r0 *1 0,0
Xsky130_fd_sc_hd__tapvpwrvgnd_1_230 VSS VDD sky130_fd_sc_hd__tapvpwrvgnd_1
* cell instance sky130_fd_sc_hd__tapvpwrvgnd_1_231 r0 *1 0,0
Xsky130_fd_sc_hd__tapvpwrvgnd_1_231 VSS VDD sky130_fd_sc_hd__tapvpwrvgnd_1
* cell instance sky130_fd_sc_hd__tapvpwrvgnd_1_232 r0 *1 0,0
Xsky130_fd_sc_hd__tapvpwrvgnd_1_232 VSS VDD sky130_fd_sc_hd__tapvpwrvgnd_1
* cell instance sky130_fd_sc_hd__tapvpwrvgnd_1_233 r0 *1 0,0
Xsky130_fd_sc_hd__tapvpwrvgnd_1_233 VSS VDD sky130_fd_sc_hd__tapvpwrvgnd_1
* cell instance sky130_fd_sc_hd__tapvpwrvgnd_1_234 r0 *1 0,0
Xsky130_fd_sc_hd__tapvpwrvgnd_1_234 VSS VDD sky130_fd_sc_hd__tapvpwrvgnd_1
* cell instance sky130_fd_sc_hd__tapvpwrvgnd_1_235 r0 *1 0,0
Xsky130_fd_sc_hd__tapvpwrvgnd_1_235 VSS VDD sky130_fd_sc_hd__tapvpwrvgnd_1
* cell instance sky130_fd_sc_hd__tapvpwrvgnd_1_236 r0 *1 0,0
Xsky130_fd_sc_hd__tapvpwrvgnd_1_236 VSS VDD sky130_fd_sc_hd__tapvpwrvgnd_1
* cell instance sky130_fd_sc_hd__tapvpwrvgnd_1_237 r0 *1 0,0
Xsky130_fd_sc_hd__tapvpwrvgnd_1_237 VSS VDD sky130_fd_sc_hd__tapvpwrvgnd_1
* cell instance sky130_fd_sc_hd__tapvpwrvgnd_1_238 r0 *1 0,0
Xsky130_fd_sc_hd__tapvpwrvgnd_1_238 VSS VDD sky130_fd_sc_hd__tapvpwrvgnd_1
* cell instance sky130_fd_sc_hd__tapvpwrvgnd_1_239 r0 *1 0,0
Xsky130_fd_sc_hd__tapvpwrvgnd_1_239 VSS VDD sky130_fd_sc_hd__tapvpwrvgnd_1
* cell instance sky130_fd_sc_hd__tapvpwrvgnd_1_240 r0 *1 0,0
Xsky130_fd_sc_hd__tapvpwrvgnd_1_240 VSS VDD sky130_fd_sc_hd__tapvpwrvgnd_1
* cell instance sky130_fd_sc_hd__tapvpwrvgnd_1_241 r0 *1 0,0
Xsky130_fd_sc_hd__tapvpwrvgnd_1_241 VSS VDD sky130_fd_sc_hd__tapvpwrvgnd_1
* cell instance sky130_fd_sc_hd__tapvpwrvgnd_1_242 r0 *1 0,0
Xsky130_fd_sc_hd__tapvpwrvgnd_1_242 VSS VDD sky130_fd_sc_hd__tapvpwrvgnd_1
* cell instance sky130_fd_sc_hd__tapvpwrvgnd_1_243 r0 *1 0,0
Xsky130_fd_sc_hd__tapvpwrvgnd_1_243 VSS VDD sky130_fd_sc_hd__tapvpwrvgnd_1
* cell instance sky130_fd_sc_hd__tapvpwrvgnd_1_244 r0 *1 0,0
Xsky130_fd_sc_hd__tapvpwrvgnd_1_244 VSS VDD sky130_fd_sc_hd__tapvpwrvgnd_1
* cell instance sky130_fd_sc_hd__tapvpwrvgnd_1_245 r0 *1 0,0
Xsky130_fd_sc_hd__tapvpwrvgnd_1_245 VSS VDD sky130_fd_sc_hd__tapvpwrvgnd_1
* cell instance sky130_fd_sc_hd__tapvpwrvgnd_1_246 r0 *1 0,0
Xsky130_fd_sc_hd__tapvpwrvgnd_1_246 VSS VDD sky130_fd_sc_hd__tapvpwrvgnd_1
* cell instance sky130_fd_sc_hd__tapvpwrvgnd_1_247 r0 *1 0,0
Xsky130_fd_sc_hd__tapvpwrvgnd_1_247 VSS VDD sky130_fd_sc_hd__tapvpwrvgnd_1
* cell instance sky130_fd_sc_hd__tapvpwrvgnd_1_248 r0 *1 0,0
Xsky130_fd_sc_hd__tapvpwrvgnd_1_248 VSS VDD sky130_fd_sc_hd__tapvpwrvgnd_1
* cell instance sky130_fd_sc_hd__tapvpwrvgnd_1_249 r0 *1 0,0
Xsky130_fd_sc_hd__tapvpwrvgnd_1_249 VSS VDD sky130_fd_sc_hd__tapvpwrvgnd_1
* cell instance sky130_fd_sc_hd__tapvpwrvgnd_1_250 r0 *1 0,0
Xsky130_fd_sc_hd__tapvpwrvgnd_1_250 VSS VDD sky130_fd_sc_hd__tapvpwrvgnd_1
* cell instance sky130_fd_sc_hd__tapvpwrvgnd_1_251 r0 *1 0,0
Xsky130_fd_sc_hd__tapvpwrvgnd_1_251 VSS VDD sky130_fd_sc_hd__tapvpwrvgnd_1
* cell instance sky130_fd_sc_hd__tapvpwrvgnd_1_252 r0 *1 0,0
Xsky130_fd_sc_hd__tapvpwrvgnd_1_252 VSS VDD sky130_fd_sc_hd__tapvpwrvgnd_1
* cell instance sky130_fd_sc_hd__tapvpwrvgnd_1_253 r0 *1 0,0
Xsky130_fd_sc_hd__tapvpwrvgnd_1_253 VSS VDD sky130_fd_sc_hd__tapvpwrvgnd_1
* cell instance sky130_fd_sc_hd__tapvpwrvgnd_1_254 r0 *1 0,0
Xsky130_fd_sc_hd__tapvpwrvgnd_1_254 VSS VDD sky130_fd_sc_hd__tapvpwrvgnd_1
* cell instance sky130_fd_sc_hd__tapvpwrvgnd_1_255 r0 *1 0,0
Xsky130_fd_sc_hd__tapvpwrvgnd_1_255 VSS VDD sky130_fd_sc_hd__tapvpwrvgnd_1
* cell instance sky130_fd_sc_hd__tapvpwrvgnd_1_256 r0 *1 0,0
Xsky130_fd_sc_hd__tapvpwrvgnd_1_256 VSS VDD sky130_fd_sc_hd__tapvpwrvgnd_1
* cell instance sky130_fd_sc_hd__tapvpwrvgnd_1_257 r0 *1 0,0
Xsky130_fd_sc_hd__tapvpwrvgnd_1_257 VSS VDD sky130_fd_sc_hd__tapvpwrvgnd_1
* cell instance sky130_fd_sc_hd__tapvpwrvgnd_1_258 r0 *1 0,0
Xsky130_fd_sc_hd__tapvpwrvgnd_1_258 VSS VDD sky130_fd_sc_hd__tapvpwrvgnd_1
* cell instance sky130_fd_sc_hd__tapvpwrvgnd_1_259 r0 *1 0,0
Xsky130_fd_sc_hd__tapvpwrvgnd_1_259 VSS VDD sky130_fd_sc_hd__tapvpwrvgnd_1
* cell instance sky130_fd_sc_hd__tapvpwrvgnd_1_260 r0 *1 0,0
Xsky130_fd_sc_hd__tapvpwrvgnd_1_260 VSS VDD sky130_fd_sc_hd__tapvpwrvgnd_1
* cell instance sky130_fd_sc_hd__tapvpwrvgnd_1_261 r0 *1 0,0
Xsky130_fd_sc_hd__tapvpwrvgnd_1_261 VSS VDD sky130_fd_sc_hd__tapvpwrvgnd_1
* cell instance sky130_fd_sc_hd__tapvpwrvgnd_1_262 r0 *1 0,0
Xsky130_fd_sc_hd__tapvpwrvgnd_1_262 VSS VDD sky130_fd_sc_hd__tapvpwrvgnd_1
* cell instance sky130_fd_sc_hd__tapvpwrvgnd_1_263 r0 *1 0,0
Xsky130_fd_sc_hd__tapvpwrvgnd_1_263 VSS VDD sky130_fd_sc_hd__tapvpwrvgnd_1
* cell instance sky130_fd_sc_hd__tapvpwrvgnd_1_264 r0 *1 0,0
Xsky130_fd_sc_hd__tapvpwrvgnd_1_264 VSS VDD sky130_fd_sc_hd__tapvpwrvgnd_1
* cell instance sky130_fd_sc_hd__tapvpwrvgnd_1_265 r0 *1 0,0
Xsky130_fd_sc_hd__tapvpwrvgnd_1_265 VSS VDD sky130_fd_sc_hd__tapvpwrvgnd_1
* cell instance sky130_fd_sc_hd__tapvpwrvgnd_1_266 r0 *1 0,0
Xsky130_fd_sc_hd__tapvpwrvgnd_1_266 VSS VDD sky130_fd_sc_hd__tapvpwrvgnd_1
* cell instance sky130_fd_sc_hd__tapvpwrvgnd_1_267 r0 *1 0,0
Xsky130_fd_sc_hd__tapvpwrvgnd_1_267 VSS VDD sky130_fd_sc_hd__tapvpwrvgnd_1
* cell instance sky130_fd_sc_hd__tapvpwrvgnd_1_268 r0 *1 0,0
Xsky130_fd_sc_hd__tapvpwrvgnd_1_268 VSS VDD sky130_fd_sc_hd__tapvpwrvgnd_1
* cell instance sky130_fd_sc_hd__tapvpwrvgnd_1_269 r0 *1 0,0
Xsky130_fd_sc_hd__tapvpwrvgnd_1_269 VSS VDD sky130_fd_sc_hd__tapvpwrvgnd_1
* cell instance sky130_fd_sc_hd__tapvpwrvgnd_1_270 r0 *1 0,0
Xsky130_fd_sc_hd__tapvpwrvgnd_1_270 VSS VDD sky130_fd_sc_hd__tapvpwrvgnd_1
* cell instance sky130_fd_sc_hd__tapvpwrvgnd_1_271 r0 *1 0,0
Xsky130_fd_sc_hd__tapvpwrvgnd_1_271 VSS VDD sky130_fd_sc_hd__tapvpwrvgnd_1
* cell instance sky130_fd_sc_hd__tapvpwrvgnd_1_272 r0 *1 0,0
Xsky130_fd_sc_hd__tapvpwrvgnd_1_272 VSS VDD sky130_fd_sc_hd__tapvpwrvgnd_1
* cell instance sky130_fd_sc_hd__tapvpwrvgnd_1_273 r0 *1 0,0
Xsky130_fd_sc_hd__tapvpwrvgnd_1_273 VSS VDD sky130_fd_sc_hd__tapvpwrvgnd_1
* cell instance sky130_fd_sc_hd__tapvpwrvgnd_1_274 r0 *1 0,0
Xsky130_fd_sc_hd__tapvpwrvgnd_1_274 VSS VDD sky130_fd_sc_hd__tapvpwrvgnd_1
* cell instance sky130_fd_sc_hd__tapvpwrvgnd_1_275 r0 *1 0,0
Xsky130_fd_sc_hd__tapvpwrvgnd_1_275 VSS VDD sky130_fd_sc_hd__tapvpwrvgnd_1
* cell instance sky130_fd_sc_hd__tapvpwrvgnd_1_276 r0 *1 0,0
Xsky130_fd_sc_hd__tapvpwrvgnd_1_276 VSS VDD sky130_fd_sc_hd__tapvpwrvgnd_1
* cell instance sky130_fd_sc_hd__tapvpwrvgnd_1_277 r0 *1 0,0
Xsky130_fd_sc_hd__tapvpwrvgnd_1_277 VSS VDD sky130_fd_sc_hd__tapvpwrvgnd_1
* cell instance sky130_fd_sc_hd__tapvpwrvgnd_1_278 r0 *1 0,0
Xsky130_fd_sc_hd__tapvpwrvgnd_1_278 VSS VDD sky130_fd_sc_hd__tapvpwrvgnd_1
* cell instance sky130_fd_sc_hd__tapvpwrvgnd_1_279 r0 *1 0,0
Xsky130_fd_sc_hd__tapvpwrvgnd_1_279 VSS VDD sky130_fd_sc_hd__tapvpwrvgnd_1
* cell instance sky130_fd_sc_hd__tapvpwrvgnd_1_280 r0 *1 0,0
Xsky130_fd_sc_hd__tapvpwrvgnd_1_280 VSS VDD sky130_fd_sc_hd__tapvpwrvgnd_1
* cell instance sky130_fd_sc_hd__tapvpwrvgnd_1_281 r0 *1 0,0
Xsky130_fd_sc_hd__tapvpwrvgnd_1_281 VSS VDD sky130_fd_sc_hd__tapvpwrvgnd_1
* cell instance sky130_fd_sc_hd__tapvpwrvgnd_1_282 r0 *1 0,0
Xsky130_fd_sc_hd__tapvpwrvgnd_1_282 VSS VDD sky130_fd_sc_hd__tapvpwrvgnd_1
* cell instance sky130_fd_sc_hd__tapvpwrvgnd_1_283 r0 *1 0,0
Xsky130_fd_sc_hd__tapvpwrvgnd_1_283 VSS VDD sky130_fd_sc_hd__tapvpwrvgnd_1
* cell instance sky130_fd_sc_hd__tapvpwrvgnd_1_284 r0 *1 0,0
Xsky130_fd_sc_hd__tapvpwrvgnd_1_284 VSS VDD sky130_fd_sc_hd__tapvpwrvgnd_1
* cell instance sky130_fd_sc_hd__tapvpwrvgnd_1_285 r0 *1 0,0
Xsky130_fd_sc_hd__tapvpwrvgnd_1_285 VSS VDD sky130_fd_sc_hd__tapvpwrvgnd_1
* cell instance sky130_fd_sc_hd__tapvpwrvgnd_1_286 r0 *1 0,0
Xsky130_fd_sc_hd__tapvpwrvgnd_1_286 VSS VDD sky130_fd_sc_hd__tapvpwrvgnd_1
* cell instance sky130_fd_sc_hd__tapvpwrvgnd_1_287 r0 *1 0,0
Xsky130_fd_sc_hd__tapvpwrvgnd_1_287 VSS VDD sky130_fd_sc_hd__tapvpwrvgnd_1
* cell instance sky130_fd_sc_hd__tapvpwrvgnd_1_288 r0 *1 0,0
Xsky130_fd_sc_hd__tapvpwrvgnd_1_288 VSS VDD sky130_fd_sc_hd__tapvpwrvgnd_1
* cell instance sky130_fd_sc_hd__tapvpwrvgnd_1_289 r0 *1 0,0
Xsky130_fd_sc_hd__tapvpwrvgnd_1_289 VSS VDD sky130_fd_sc_hd__tapvpwrvgnd_1
* cell instance sky130_fd_sc_hd__tapvpwrvgnd_1_290 r0 *1 0,0
Xsky130_fd_sc_hd__tapvpwrvgnd_1_290 VSS VDD sky130_fd_sc_hd__tapvpwrvgnd_1
* cell instance sky130_fd_sc_hd__tapvpwrvgnd_1_291 r0 *1 0,0
Xsky130_fd_sc_hd__tapvpwrvgnd_1_291 VSS VDD sky130_fd_sc_hd__tapvpwrvgnd_1
* cell instance sky130_fd_sc_hd__tapvpwrvgnd_1_292 r0 *1 0,0
Xsky130_fd_sc_hd__tapvpwrvgnd_1_292 VSS VDD sky130_fd_sc_hd__tapvpwrvgnd_1
* cell instance sky130_fd_sc_hd__tapvpwrvgnd_1_293 r0 *1 0,0
Xsky130_fd_sc_hd__tapvpwrvgnd_1_293 VSS VDD sky130_fd_sc_hd__tapvpwrvgnd_1
* cell instance sky130_fd_sc_hd__tapvpwrvgnd_1_294 r0 *1 0,0
Xsky130_fd_sc_hd__tapvpwrvgnd_1_294 VSS VDD sky130_fd_sc_hd__tapvpwrvgnd_1
* cell instance sky130_fd_sc_hd__tapvpwrvgnd_1_295 r0 *1 0,0
Xsky130_fd_sc_hd__tapvpwrvgnd_1_295 VSS VDD sky130_fd_sc_hd__tapvpwrvgnd_1
* cell instance sky130_fd_sc_hd__tapvpwrvgnd_1_296 r0 *1 0,0
Xsky130_fd_sc_hd__tapvpwrvgnd_1_296 VSS VDD sky130_fd_sc_hd__tapvpwrvgnd_1
* cell instance sky130_fd_sc_hd__tapvpwrvgnd_1_297 r0 *1 0,0
Xsky130_fd_sc_hd__tapvpwrvgnd_1_297 VSS VDD sky130_fd_sc_hd__tapvpwrvgnd_1
* cell instance sky130_fd_sc_hd__tapvpwrvgnd_1_298 r0 *1 0,0
Xsky130_fd_sc_hd__tapvpwrvgnd_1_298 VSS VDD sky130_fd_sc_hd__tapvpwrvgnd_1
* cell instance sky130_fd_sc_hd__tapvpwrvgnd_1_299 r0 *1 0,0
Xsky130_fd_sc_hd__tapvpwrvgnd_1_299 VSS VDD sky130_fd_sc_hd__tapvpwrvgnd_1
* cell instance sky130_fd_sc_hd__tapvpwrvgnd_1_300 r0 *1 0,0
Xsky130_fd_sc_hd__tapvpwrvgnd_1_300 VSS VDD sky130_fd_sc_hd__tapvpwrvgnd_1
* cell instance sky130_fd_sc_hd__tapvpwrvgnd_1_301 r0 *1 0,0
Xsky130_fd_sc_hd__tapvpwrvgnd_1_301 VSS VDD sky130_fd_sc_hd__tapvpwrvgnd_1
* cell instance sky130_fd_sc_hd__tapvpwrvgnd_1_302 r0 *1 0,0
Xsky130_fd_sc_hd__tapvpwrvgnd_1_302 VSS VDD sky130_fd_sc_hd__tapvpwrvgnd_1
* cell instance sky130_fd_sc_hd__tapvpwrvgnd_1_303 r0 *1 0,0
Xsky130_fd_sc_hd__tapvpwrvgnd_1_303 VSS VDD sky130_fd_sc_hd__tapvpwrvgnd_1
* cell instance sky130_fd_sc_hd__tapvpwrvgnd_1_304 r0 *1 0,0
Xsky130_fd_sc_hd__tapvpwrvgnd_1_304 VSS VDD sky130_fd_sc_hd__tapvpwrvgnd_1
* cell instance sky130_fd_sc_hd__tapvpwrvgnd_1_305 r0 *1 0,0
Xsky130_fd_sc_hd__tapvpwrvgnd_1_305 VSS VDD sky130_fd_sc_hd__tapvpwrvgnd_1
* cell instance sky130_fd_sc_hd__tapvpwrvgnd_1_306 r0 *1 0,0
Xsky130_fd_sc_hd__tapvpwrvgnd_1_306 VSS VDD sky130_fd_sc_hd__tapvpwrvgnd_1
* cell instance sky130_fd_sc_hd__tapvpwrvgnd_1_307 r0 *1 0,0
Xsky130_fd_sc_hd__tapvpwrvgnd_1_307 VSS VDD sky130_fd_sc_hd__tapvpwrvgnd_1
* cell instance sky130_fd_sc_hd__tapvpwrvgnd_1_308 r0 *1 0,0
Xsky130_fd_sc_hd__tapvpwrvgnd_1_308 VSS VDD sky130_fd_sc_hd__tapvpwrvgnd_1
* cell instance sky130_fd_sc_hd__tapvpwrvgnd_1_309 r0 *1 0,0
Xsky130_fd_sc_hd__tapvpwrvgnd_1_309 VSS VDD sky130_fd_sc_hd__tapvpwrvgnd_1
* cell instance sky130_fd_sc_hd__tapvpwrvgnd_1_310 r0 *1 0,0
Xsky130_fd_sc_hd__tapvpwrvgnd_1_310 VSS VDD sky130_fd_sc_hd__tapvpwrvgnd_1
* cell instance sky130_fd_sc_hd__tapvpwrvgnd_1_311 r0 *1 0,0
Xsky130_fd_sc_hd__tapvpwrvgnd_1_311 VSS VDD sky130_fd_sc_hd__tapvpwrvgnd_1
* cell instance sky130_fd_sc_hd__tapvpwrvgnd_1_312 r0 *1 0,0
Xsky130_fd_sc_hd__tapvpwrvgnd_1_312 VSS VDD sky130_fd_sc_hd__tapvpwrvgnd_1
* cell instance sky130_fd_sc_hd__tapvpwrvgnd_1_313 r0 *1 0,0
Xsky130_fd_sc_hd__tapvpwrvgnd_1_313 VSS VDD sky130_fd_sc_hd__tapvpwrvgnd_1
* cell instance sky130_fd_sc_hd__tapvpwrvgnd_1_314 r0 *1 0,0
Xsky130_fd_sc_hd__tapvpwrvgnd_1_314 VSS VDD sky130_fd_sc_hd__tapvpwrvgnd_1
* cell instance sky130_fd_sc_hd__tapvpwrvgnd_1_315 r0 *1 0,0
Xsky130_fd_sc_hd__tapvpwrvgnd_1_315 VSS VDD sky130_fd_sc_hd__tapvpwrvgnd_1
* cell instance sky130_fd_sc_hd__tapvpwrvgnd_1_316 r0 *1 0,0
Xsky130_fd_sc_hd__tapvpwrvgnd_1_316 VSS VDD sky130_fd_sc_hd__tapvpwrvgnd_1
* cell instance sky130_fd_sc_hd__tapvpwrvgnd_1_317 r0 *1 0,0
Xsky130_fd_sc_hd__tapvpwrvgnd_1_317 VSS VDD sky130_fd_sc_hd__tapvpwrvgnd_1
* cell instance sky130_fd_sc_hd__tapvpwrvgnd_1_318 r0 *1 0,0
Xsky130_fd_sc_hd__tapvpwrvgnd_1_318 VSS VDD sky130_fd_sc_hd__tapvpwrvgnd_1
* cell instance sky130_fd_sc_hd__tapvpwrvgnd_1_319 r0 *1 0,0
Xsky130_fd_sc_hd__tapvpwrvgnd_1_319 VSS VDD sky130_fd_sc_hd__tapvpwrvgnd_1
* cell instance sky130_fd_sc_hd__tapvpwrvgnd_1_320 r0 *1 0,0
Xsky130_fd_sc_hd__tapvpwrvgnd_1_320 VSS VDD sky130_fd_sc_hd__tapvpwrvgnd_1
* cell instance sky130_fd_sc_hd__tapvpwrvgnd_1_321 r0 *1 0,0
Xsky130_fd_sc_hd__tapvpwrvgnd_1_321 VSS VDD sky130_fd_sc_hd__tapvpwrvgnd_1
* cell instance sky130_fd_sc_hd__tapvpwrvgnd_1_322 r0 *1 0,0
Xsky130_fd_sc_hd__tapvpwrvgnd_1_322 VSS VDD sky130_fd_sc_hd__tapvpwrvgnd_1
* cell instance sky130_fd_sc_hd__tapvpwrvgnd_1_323 r0 *1 0,0
Xsky130_fd_sc_hd__tapvpwrvgnd_1_323 VSS VDD sky130_fd_sc_hd__tapvpwrvgnd_1
* cell instance sky130_fd_sc_hd__tapvpwrvgnd_1_324 r0 *1 0,0
Xsky130_fd_sc_hd__tapvpwrvgnd_1_324 VSS VDD sky130_fd_sc_hd__tapvpwrvgnd_1
* cell instance sky130_fd_sc_hd__tapvpwrvgnd_1_325 r0 *1 0,0
Xsky130_fd_sc_hd__tapvpwrvgnd_1_325 VSS VDD sky130_fd_sc_hd__tapvpwrvgnd_1
* cell instance sky130_fd_sc_hd__tapvpwrvgnd_1_326 r0 *1 0,0
Xsky130_fd_sc_hd__tapvpwrvgnd_1_326 VSS VDD sky130_fd_sc_hd__tapvpwrvgnd_1
* cell instance sky130_fd_sc_hd__tapvpwrvgnd_1_327 r0 *1 0,0
Xsky130_fd_sc_hd__tapvpwrvgnd_1_327 VSS VDD sky130_fd_sc_hd__tapvpwrvgnd_1
* cell instance sky130_fd_sc_hd__tapvpwrvgnd_1_328 r0 *1 0,0
Xsky130_fd_sc_hd__tapvpwrvgnd_1_328 VSS VDD sky130_fd_sc_hd__tapvpwrvgnd_1
* cell instance sky130_fd_sc_hd__tapvpwrvgnd_1_329 r0 *1 0,0
Xsky130_fd_sc_hd__tapvpwrvgnd_1_329 VSS VDD sky130_fd_sc_hd__tapvpwrvgnd_1
* cell instance sky130_fd_sc_hd__tapvpwrvgnd_1_330 r0 *1 0,0
Xsky130_fd_sc_hd__tapvpwrvgnd_1_330 VSS VDD sky130_fd_sc_hd__tapvpwrvgnd_1
* cell instance sky130_fd_sc_hd__tapvpwrvgnd_1_331 r0 *1 0,0
Xsky130_fd_sc_hd__tapvpwrvgnd_1_331 VSS VDD sky130_fd_sc_hd__tapvpwrvgnd_1
* cell instance sky130_fd_sc_hd__tapvpwrvgnd_1_332 r0 *1 0,0
Xsky130_fd_sc_hd__tapvpwrvgnd_1_332 VSS VDD sky130_fd_sc_hd__tapvpwrvgnd_1
* cell instance sky130_fd_sc_hd__tapvpwrvgnd_1_333 r0 *1 0,0
Xsky130_fd_sc_hd__tapvpwrvgnd_1_333 VSS VDD sky130_fd_sc_hd__tapvpwrvgnd_1
* cell instance sky130_fd_sc_hd__tapvpwrvgnd_1_334 r0 *1 0,0
Xsky130_fd_sc_hd__tapvpwrvgnd_1_334 VSS VDD sky130_fd_sc_hd__tapvpwrvgnd_1
* cell instance sky130_fd_sc_hd__tapvpwrvgnd_1_335 r0 *1 0,0
Xsky130_fd_sc_hd__tapvpwrvgnd_1_335 VSS VDD sky130_fd_sc_hd__tapvpwrvgnd_1
* cell instance sky130_fd_sc_hd__tapvpwrvgnd_1_336 r0 *1 0,0
Xsky130_fd_sc_hd__tapvpwrvgnd_1_336 VSS VDD sky130_fd_sc_hd__tapvpwrvgnd_1
* cell instance sky130_fd_sc_hd__tapvpwrvgnd_1_337 r0 *1 0,0
Xsky130_fd_sc_hd__tapvpwrvgnd_1_337 VSS VDD sky130_fd_sc_hd__tapvpwrvgnd_1
* cell instance sky130_fd_sc_hd__tapvpwrvgnd_1_338 r0 *1 0,0
Xsky130_fd_sc_hd__tapvpwrvgnd_1_338 VSS VDD sky130_fd_sc_hd__tapvpwrvgnd_1
* cell instance sky130_fd_sc_hd__tapvpwrvgnd_1_339 r0 *1 0,0
Xsky130_fd_sc_hd__tapvpwrvgnd_1_339 VSS VDD sky130_fd_sc_hd__tapvpwrvgnd_1
* cell instance sky130_fd_sc_hd__tapvpwrvgnd_1_340 r0 *1 0,0
Xsky130_fd_sc_hd__tapvpwrvgnd_1_340 VSS VDD sky130_fd_sc_hd__tapvpwrvgnd_1
* cell instance sky130_fd_sc_hd__tapvpwrvgnd_1_341 r0 *1 0,0
Xsky130_fd_sc_hd__tapvpwrvgnd_1_341 VSS VDD sky130_fd_sc_hd__tapvpwrvgnd_1
* cell instance sky130_fd_sc_hd__tapvpwrvgnd_1_342 r0 *1 0,0
Xsky130_fd_sc_hd__tapvpwrvgnd_1_342 VSS VDD sky130_fd_sc_hd__tapvpwrvgnd_1
* cell instance sky130_fd_sc_hd__tapvpwrvgnd_1_343 r0 *1 0,0
Xsky130_fd_sc_hd__tapvpwrvgnd_1_343 VSS VDD sky130_fd_sc_hd__tapvpwrvgnd_1
* cell instance sky130_fd_sc_hd__tapvpwrvgnd_1_344 r0 *1 0,0
Xsky130_fd_sc_hd__tapvpwrvgnd_1_344 VSS VDD sky130_fd_sc_hd__tapvpwrvgnd_1
* cell instance sky130_fd_sc_hd__tapvpwrvgnd_1_345 r0 *1 0,0
Xsky130_fd_sc_hd__tapvpwrvgnd_1_345 VSS VDD sky130_fd_sc_hd__tapvpwrvgnd_1
* cell instance sky130_fd_sc_hd__tapvpwrvgnd_1_346 r0 *1 0,0
Xsky130_fd_sc_hd__tapvpwrvgnd_1_346 VSS VDD sky130_fd_sc_hd__tapvpwrvgnd_1
* cell instance sky130_fd_sc_hd__tapvpwrvgnd_1_347 r0 *1 0,0
Xsky130_fd_sc_hd__tapvpwrvgnd_1_347 VSS VDD sky130_fd_sc_hd__tapvpwrvgnd_1
* cell instance sky130_fd_sc_hd__tapvpwrvgnd_1_348 r0 *1 0,0
Xsky130_fd_sc_hd__tapvpwrvgnd_1_348 VSS VDD sky130_fd_sc_hd__tapvpwrvgnd_1
* cell instance sky130_fd_sc_hd__tapvpwrvgnd_1_349 r0 *1 0,0
Xsky130_fd_sc_hd__tapvpwrvgnd_1_349 VSS VDD sky130_fd_sc_hd__tapvpwrvgnd_1
* cell instance sky130_fd_sc_hd__tapvpwrvgnd_1_350 r0 *1 0,0
Xsky130_fd_sc_hd__tapvpwrvgnd_1_350 VSS VDD sky130_fd_sc_hd__tapvpwrvgnd_1
* cell instance sky130_fd_sc_hd__tapvpwrvgnd_1_351 r0 *1 0,0
Xsky130_fd_sc_hd__tapvpwrvgnd_1_351 VSS VDD sky130_fd_sc_hd__tapvpwrvgnd_1
* cell instance sky130_fd_sc_hd__tapvpwrvgnd_1_352 r0 *1 0,0
Xsky130_fd_sc_hd__tapvpwrvgnd_1_352 VSS VDD sky130_fd_sc_hd__tapvpwrvgnd_1
* cell instance sky130_fd_sc_hd__tapvpwrvgnd_1_353 r0 *1 0,0
Xsky130_fd_sc_hd__tapvpwrvgnd_1_353 VSS VDD sky130_fd_sc_hd__tapvpwrvgnd_1
* cell instance sky130_fd_sc_hd__tapvpwrvgnd_1_354 r0 *1 0,0
Xsky130_fd_sc_hd__tapvpwrvgnd_1_354 VSS VDD sky130_fd_sc_hd__tapvpwrvgnd_1
* cell instance sky130_fd_sc_hd__tapvpwrvgnd_1_355 r0 *1 0,0
Xsky130_fd_sc_hd__tapvpwrvgnd_1_355 VSS VDD sky130_fd_sc_hd__tapvpwrvgnd_1
* cell instance sky130_fd_sc_hd__tapvpwrvgnd_1_356 r0 *1 0,0
Xsky130_fd_sc_hd__tapvpwrvgnd_1_356 VSS VDD sky130_fd_sc_hd__tapvpwrvgnd_1
* cell instance sky130_fd_sc_hd__tapvpwrvgnd_1_357 r0 *1 0,0
Xsky130_fd_sc_hd__tapvpwrvgnd_1_357 VSS VDD sky130_fd_sc_hd__tapvpwrvgnd_1
* cell instance sky130_fd_sc_hd__tapvpwrvgnd_1_358 r0 *1 0,0
Xsky130_fd_sc_hd__tapvpwrvgnd_1_358 VSS VDD sky130_fd_sc_hd__tapvpwrvgnd_1
* cell instance sky130_fd_sc_hd__tapvpwrvgnd_1_359 r0 *1 0,0
Xsky130_fd_sc_hd__tapvpwrvgnd_1_359 VSS VDD sky130_fd_sc_hd__tapvpwrvgnd_1
* cell instance sky130_fd_sc_hd__tapvpwrvgnd_1_360 r0 *1 0,0
Xsky130_fd_sc_hd__tapvpwrvgnd_1_360 VSS VDD sky130_fd_sc_hd__tapvpwrvgnd_1
* cell instance sky130_fd_sc_hd__tapvpwrvgnd_1_361 r0 *1 0,0
Xsky130_fd_sc_hd__tapvpwrvgnd_1_361 VSS VDD sky130_fd_sc_hd__tapvpwrvgnd_1
* cell instance sky130_fd_sc_hd__tapvpwrvgnd_1_362 r0 *1 0,0
Xsky130_fd_sc_hd__tapvpwrvgnd_1_362 VSS VDD sky130_fd_sc_hd__tapvpwrvgnd_1
* cell instance sky130_fd_sc_hd__tapvpwrvgnd_1_363 r0 *1 0,0
Xsky130_fd_sc_hd__tapvpwrvgnd_1_363 VSS VDD sky130_fd_sc_hd__tapvpwrvgnd_1
* cell instance sky130_fd_sc_hd__tapvpwrvgnd_1_364 r0 *1 0,0
Xsky130_fd_sc_hd__tapvpwrvgnd_1_364 VSS VDD sky130_fd_sc_hd__tapvpwrvgnd_1
* cell instance sky130_fd_sc_hd__tapvpwrvgnd_1_365 r0 *1 0,0
Xsky130_fd_sc_hd__tapvpwrvgnd_1_365 VSS VDD sky130_fd_sc_hd__tapvpwrvgnd_1
* cell instance sky130_fd_sc_hd__tapvpwrvgnd_1_366 r0 *1 0,0
Xsky130_fd_sc_hd__tapvpwrvgnd_1_366 VSS VDD sky130_fd_sc_hd__tapvpwrvgnd_1
* cell instance sky130_fd_sc_hd__tapvpwrvgnd_1_367 r0 *1 0,0
Xsky130_fd_sc_hd__tapvpwrvgnd_1_367 VSS VDD sky130_fd_sc_hd__tapvpwrvgnd_1
* cell instance sky130_fd_sc_hd__tapvpwrvgnd_1_368 r0 *1 0,0
Xsky130_fd_sc_hd__tapvpwrvgnd_1_368 VSS VDD sky130_fd_sc_hd__tapvpwrvgnd_1
* cell instance sky130_fd_sc_hd__tapvpwrvgnd_1_369 r0 *1 0,0
Xsky130_fd_sc_hd__tapvpwrvgnd_1_369 VSS VDD sky130_fd_sc_hd__tapvpwrvgnd_1
* cell instance sky130_fd_sc_hd__tapvpwrvgnd_1_370 r0 *1 0,0
Xsky130_fd_sc_hd__tapvpwrvgnd_1_370 VSS VDD sky130_fd_sc_hd__tapvpwrvgnd_1
* cell instance sky130_fd_sc_hd__tapvpwrvgnd_1_371 r0 *1 0,0
Xsky130_fd_sc_hd__tapvpwrvgnd_1_371 VSS VDD sky130_fd_sc_hd__tapvpwrvgnd_1
* cell instance sky130_fd_sc_hd__tapvpwrvgnd_1_372 r0 *1 0,0
Xsky130_fd_sc_hd__tapvpwrvgnd_1_372 VSS VDD sky130_fd_sc_hd__tapvpwrvgnd_1
* cell instance sky130_fd_sc_hd__tapvpwrvgnd_1_373 r0 *1 0,0
Xsky130_fd_sc_hd__tapvpwrvgnd_1_373 VSS VDD sky130_fd_sc_hd__tapvpwrvgnd_1
* cell instance sky130_fd_sc_hd__tapvpwrvgnd_1_374 r0 *1 0,0
Xsky130_fd_sc_hd__tapvpwrvgnd_1_374 VSS VDD sky130_fd_sc_hd__tapvpwrvgnd_1
* cell instance sky130_fd_sc_hd__tapvpwrvgnd_1_375 r0 *1 0,0
Xsky130_fd_sc_hd__tapvpwrvgnd_1_375 VSS VDD sky130_fd_sc_hd__tapvpwrvgnd_1
* cell instance sky130_fd_sc_hd__tapvpwrvgnd_1_376 r0 *1 0,0
Xsky130_fd_sc_hd__tapvpwrvgnd_1_376 VSS VDD sky130_fd_sc_hd__tapvpwrvgnd_1
* cell instance sky130_fd_sc_hd__tapvpwrvgnd_1_377 r0 *1 0,0
Xsky130_fd_sc_hd__tapvpwrvgnd_1_377 VSS VDD sky130_fd_sc_hd__tapvpwrvgnd_1
* cell instance sky130_fd_sc_hd__tapvpwrvgnd_1_378 r0 *1 0,0
Xsky130_fd_sc_hd__tapvpwrvgnd_1_378 VSS VDD sky130_fd_sc_hd__tapvpwrvgnd_1
* cell instance sky130_fd_sc_hd__tapvpwrvgnd_1_379 r0 *1 0,0
Xsky130_fd_sc_hd__tapvpwrvgnd_1_379 VSS VDD sky130_fd_sc_hd__tapvpwrvgnd_1
* cell instance sky130_fd_sc_hd__tapvpwrvgnd_1_380 r0 *1 0,0
Xsky130_fd_sc_hd__tapvpwrvgnd_1_380 VSS VDD sky130_fd_sc_hd__tapvpwrvgnd_1
* cell instance sky130_fd_sc_hd__tapvpwrvgnd_1_381 r0 *1 0,0
Xsky130_fd_sc_hd__tapvpwrvgnd_1_381 VSS VDD sky130_fd_sc_hd__tapvpwrvgnd_1
* cell instance sky130_fd_sc_hd__tapvpwrvgnd_1_382 r0 *1 0,0
Xsky130_fd_sc_hd__tapvpwrvgnd_1_382 VSS VDD sky130_fd_sc_hd__tapvpwrvgnd_1
* cell instance sky130_fd_sc_hd__tapvpwrvgnd_1_383 r0 *1 0,0
Xsky130_fd_sc_hd__tapvpwrvgnd_1_383 VSS VDD sky130_fd_sc_hd__tapvpwrvgnd_1
* cell instance sky130_fd_sc_hd__tapvpwrvgnd_1_384 r0 *1 0,0
Xsky130_fd_sc_hd__tapvpwrvgnd_1_384 VSS VDD sky130_fd_sc_hd__tapvpwrvgnd_1
* cell instance sky130_fd_sc_hd__tapvpwrvgnd_1_385 r0 *1 0,0
Xsky130_fd_sc_hd__tapvpwrvgnd_1_385 VSS VDD sky130_fd_sc_hd__tapvpwrvgnd_1
* cell instance sky130_fd_sc_hd__tapvpwrvgnd_1_386 r0 *1 0,0
Xsky130_fd_sc_hd__tapvpwrvgnd_1_386 VSS VDD sky130_fd_sc_hd__tapvpwrvgnd_1
* cell instance sky130_fd_sc_hd__tapvpwrvgnd_1_387 r0 *1 0,0
Xsky130_fd_sc_hd__tapvpwrvgnd_1_387 VSS VDD sky130_fd_sc_hd__tapvpwrvgnd_1
* cell instance sky130_fd_sc_hd__tapvpwrvgnd_1_388 r0 *1 0,0
Xsky130_fd_sc_hd__tapvpwrvgnd_1_388 VSS VDD sky130_fd_sc_hd__tapvpwrvgnd_1
* cell instance sky130_fd_sc_hd__tapvpwrvgnd_1_389 r0 *1 0,0
Xsky130_fd_sc_hd__tapvpwrvgnd_1_389 VSS VDD sky130_fd_sc_hd__tapvpwrvgnd_1
* cell instance sky130_fd_sc_hd__tapvpwrvgnd_1_390 r0 *1 0,0
Xsky130_fd_sc_hd__tapvpwrvgnd_1_390 VSS VDD sky130_fd_sc_hd__tapvpwrvgnd_1
* cell instance sky130_fd_sc_hd__tapvpwrvgnd_1_391 r0 *1 0,0
Xsky130_fd_sc_hd__tapvpwrvgnd_1_391 VSS VDD sky130_fd_sc_hd__tapvpwrvgnd_1
* cell instance sky130_fd_sc_hd__tapvpwrvgnd_1_392 r0 *1 0,0
Xsky130_fd_sc_hd__tapvpwrvgnd_1_392 VSS VDD sky130_fd_sc_hd__tapvpwrvgnd_1
* cell instance sky130_fd_sc_hd__tapvpwrvgnd_1_393 r0 *1 0,0
Xsky130_fd_sc_hd__tapvpwrvgnd_1_393 VSS VDD sky130_fd_sc_hd__tapvpwrvgnd_1
* cell instance sky130_fd_sc_hd__tapvpwrvgnd_1_394 r0 *1 0,0
Xsky130_fd_sc_hd__tapvpwrvgnd_1_394 VSS VDD sky130_fd_sc_hd__tapvpwrvgnd_1
* cell instance sky130_fd_sc_hd__tapvpwrvgnd_1_395 r0 *1 0,0
Xsky130_fd_sc_hd__tapvpwrvgnd_1_395 VSS VDD sky130_fd_sc_hd__tapvpwrvgnd_1
* cell instance sky130_fd_sc_hd__tapvpwrvgnd_1_396 r0 *1 0,0
Xsky130_fd_sc_hd__tapvpwrvgnd_1_396 VSS VDD sky130_fd_sc_hd__tapvpwrvgnd_1
* cell instance sky130_fd_sc_hd__tapvpwrvgnd_1_397 r0 *1 0,0
Xsky130_fd_sc_hd__tapvpwrvgnd_1_397 VSS VDD sky130_fd_sc_hd__tapvpwrvgnd_1
* cell instance sky130_fd_sc_hd__tapvpwrvgnd_1_398 r0 *1 0,0
Xsky130_fd_sc_hd__tapvpwrvgnd_1_398 VSS VDD sky130_fd_sc_hd__tapvpwrvgnd_1
* cell instance sky130_fd_sc_hd__tapvpwrvgnd_1_399 r0 *1 0,0
Xsky130_fd_sc_hd__tapvpwrvgnd_1_399 VSS VDD sky130_fd_sc_hd__tapvpwrvgnd_1
* cell instance sky130_fd_sc_hd__tapvpwrvgnd_1_400 r0 *1 0,0
Xsky130_fd_sc_hd__tapvpwrvgnd_1_400 VSS VDD sky130_fd_sc_hd__tapvpwrvgnd_1
* cell instance sky130_fd_sc_hd__tapvpwrvgnd_1_401 r0 *1 0,0
Xsky130_fd_sc_hd__tapvpwrvgnd_1_401 VSS VDD sky130_fd_sc_hd__tapvpwrvgnd_1
* cell instance sky130_fd_sc_hd__tapvpwrvgnd_1_402 r0 *1 0,0
Xsky130_fd_sc_hd__tapvpwrvgnd_1_402 VSS VDD sky130_fd_sc_hd__tapvpwrvgnd_1
* cell instance sky130_fd_sc_hd__tapvpwrvgnd_1_403 r0 *1 0,0
Xsky130_fd_sc_hd__tapvpwrvgnd_1_403 VSS VDD sky130_fd_sc_hd__tapvpwrvgnd_1
* cell instance sky130_fd_sc_hd__tapvpwrvgnd_1_404 r0 *1 0,0
Xsky130_fd_sc_hd__tapvpwrvgnd_1_404 VSS VDD sky130_fd_sc_hd__tapvpwrvgnd_1
* cell instance sky130_fd_sc_hd__tapvpwrvgnd_1_405 r0 *1 0,0
Xsky130_fd_sc_hd__tapvpwrvgnd_1_405 VSS VDD sky130_fd_sc_hd__tapvpwrvgnd_1
* cell instance sky130_fd_sc_hd__tapvpwrvgnd_1_406 r0 *1 0,0
Xsky130_fd_sc_hd__tapvpwrvgnd_1_406 VSS VDD sky130_fd_sc_hd__tapvpwrvgnd_1
* cell instance sky130_fd_sc_hd__tapvpwrvgnd_1_407 r0 *1 0,0
Xsky130_fd_sc_hd__tapvpwrvgnd_1_407 VSS VDD sky130_fd_sc_hd__tapvpwrvgnd_1
* cell instance sky130_fd_sc_hd__tapvpwrvgnd_1_408 r0 *1 0,0
Xsky130_fd_sc_hd__tapvpwrvgnd_1_408 VSS VDD sky130_fd_sc_hd__tapvpwrvgnd_1
* cell instance sky130_fd_sc_hd__tapvpwrvgnd_1_409 r0 *1 0,0
Xsky130_fd_sc_hd__tapvpwrvgnd_1_409 VSS VDD sky130_fd_sc_hd__tapvpwrvgnd_1
* cell instance sky130_fd_sc_hd__tapvpwrvgnd_1_410 r0 *1 0,0
Xsky130_fd_sc_hd__tapvpwrvgnd_1_410 VSS VDD sky130_fd_sc_hd__tapvpwrvgnd_1
* cell instance sky130_fd_sc_hd__tapvpwrvgnd_1_411 r0 *1 0,0
Xsky130_fd_sc_hd__tapvpwrvgnd_1_411 VSS VDD sky130_fd_sc_hd__tapvpwrvgnd_1
* cell instance sky130_fd_sc_hd__tapvpwrvgnd_1_412 r0 *1 0,0
Xsky130_fd_sc_hd__tapvpwrvgnd_1_412 VSS VDD sky130_fd_sc_hd__tapvpwrvgnd_1
* cell instance sky130_fd_sc_hd__tapvpwrvgnd_1_413 r0 *1 0,0
Xsky130_fd_sc_hd__tapvpwrvgnd_1_413 VSS VDD sky130_fd_sc_hd__tapvpwrvgnd_1
* cell instance sky130_fd_sc_hd__tapvpwrvgnd_1_414 r0 *1 0,0
Xsky130_fd_sc_hd__tapvpwrvgnd_1_414 VSS VDD sky130_fd_sc_hd__tapvpwrvgnd_1
* cell instance sky130_fd_sc_hd__tapvpwrvgnd_1_415 r0 *1 0,0
Xsky130_fd_sc_hd__tapvpwrvgnd_1_415 VSS VDD sky130_fd_sc_hd__tapvpwrvgnd_1
* cell instance sky130_fd_sc_hd__tapvpwrvgnd_1_416 r0 *1 0,0
Xsky130_fd_sc_hd__tapvpwrvgnd_1_416 VSS VDD sky130_fd_sc_hd__tapvpwrvgnd_1
* cell instance sky130_fd_sc_hd__tapvpwrvgnd_1_417 r0 *1 0,0
Xsky130_fd_sc_hd__tapvpwrvgnd_1_417 VSS VDD sky130_fd_sc_hd__tapvpwrvgnd_1
* cell instance sky130_fd_sc_hd__tapvpwrvgnd_1_418 r0 *1 0,0
Xsky130_fd_sc_hd__tapvpwrvgnd_1_418 VSS VDD sky130_fd_sc_hd__tapvpwrvgnd_1
* cell instance sky130_fd_sc_hd__tapvpwrvgnd_1_419 r0 *1 0,0
Xsky130_fd_sc_hd__tapvpwrvgnd_1_419 VSS VDD sky130_fd_sc_hd__tapvpwrvgnd_1
* cell instance sky130_fd_sc_hd__tapvpwrvgnd_1_420 r0 *1 0,0
Xsky130_fd_sc_hd__tapvpwrvgnd_1_420 VSS VDD sky130_fd_sc_hd__tapvpwrvgnd_1
* cell instance sky130_fd_sc_hd__tapvpwrvgnd_1_421 r0 *1 0,0
Xsky130_fd_sc_hd__tapvpwrvgnd_1_421 VSS VDD sky130_fd_sc_hd__tapvpwrvgnd_1
* cell instance sky130_fd_sc_hd__tapvpwrvgnd_1_422 r0 *1 0,0
Xsky130_fd_sc_hd__tapvpwrvgnd_1_422 VSS VDD sky130_fd_sc_hd__tapvpwrvgnd_1
* cell instance sky130_fd_sc_hd__tapvpwrvgnd_1_423 r0 *1 0,0
Xsky130_fd_sc_hd__tapvpwrvgnd_1_423 VSS VDD sky130_fd_sc_hd__tapvpwrvgnd_1
* cell instance sky130_fd_sc_hd__tapvpwrvgnd_1_424 r0 *1 0,0
Xsky130_fd_sc_hd__tapvpwrvgnd_1_424 VSS VDD sky130_fd_sc_hd__tapvpwrvgnd_1
* cell instance sky130_fd_sc_hd__tapvpwrvgnd_1_425 r0 *1 0,0
Xsky130_fd_sc_hd__tapvpwrvgnd_1_425 VSS VDD sky130_fd_sc_hd__tapvpwrvgnd_1
* cell instance sky130_fd_sc_hd__tapvpwrvgnd_1_426 r0 *1 0,0
Xsky130_fd_sc_hd__tapvpwrvgnd_1_426 VSS VDD sky130_fd_sc_hd__tapvpwrvgnd_1
* cell instance sky130_fd_sc_hd__tapvpwrvgnd_1_427 r0 *1 0,0
Xsky130_fd_sc_hd__tapvpwrvgnd_1_427 VSS VDD sky130_fd_sc_hd__tapvpwrvgnd_1
* cell instance sky130_fd_sc_hd__tapvpwrvgnd_1_428 r0 *1 0,0
Xsky130_fd_sc_hd__tapvpwrvgnd_1_428 VSS VDD sky130_fd_sc_hd__tapvpwrvgnd_1
* cell instance sky130_fd_sc_hd__tapvpwrvgnd_1_429 r0 *1 0,0
Xsky130_fd_sc_hd__tapvpwrvgnd_1_429 VSS VDD sky130_fd_sc_hd__tapvpwrvgnd_1
* cell instance sky130_fd_sc_hd__tapvpwrvgnd_1_430 r0 *1 0,0
Xsky130_fd_sc_hd__tapvpwrvgnd_1_430 VSS VDD sky130_fd_sc_hd__tapvpwrvgnd_1
* cell instance sky130_fd_sc_hd__tapvpwrvgnd_1_431 r0 *1 0,0
Xsky130_fd_sc_hd__tapvpwrvgnd_1_431 VSS VDD sky130_fd_sc_hd__tapvpwrvgnd_1
* cell instance sky130_fd_sc_hd__tapvpwrvgnd_1_432 r0 *1 0,0
Xsky130_fd_sc_hd__tapvpwrvgnd_1_432 VSS VDD sky130_fd_sc_hd__tapvpwrvgnd_1
* cell instance sky130_fd_sc_hd__tapvpwrvgnd_1_433 r0 *1 0,0
Xsky130_fd_sc_hd__tapvpwrvgnd_1_433 VSS VDD sky130_fd_sc_hd__tapvpwrvgnd_1
* cell instance sky130_fd_sc_hd__tapvpwrvgnd_1_434 r0 *1 0,0
Xsky130_fd_sc_hd__tapvpwrvgnd_1_434 VSS VDD sky130_fd_sc_hd__tapvpwrvgnd_1
* cell instance sky130_fd_sc_hd__tapvpwrvgnd_1_435 r0 *1 0,0
Xsky130_fd_sc_hd__tapvpwrvgnd_1_435 VSS VDD sky130_fd_sc_hd__tapvpwrvgnd_1
* cell instance sky130_fd_sc_hd__tapvpwrvgnd_1_436 r0 *1 0,0
Xsky130_fd_sc_hd__tapvpwrvgnd_1_436 VSS VDD sky130_fd_sc_hd__tapvpwrvgnd_1
* cell instance sky130_fd_sc_hd__tapvpwrvgnd_1_437 r0 *1 0,0
Xsky130_fd_sc_hd__tapvpwrvgnd_1_437 VSS VDD sky130_fd_sc_hd__tapvpwrvgnd_1
* cell instance sky130_fd_sc_hd__tapvpwrvgnd_1_438 r0 *1 0,0
Xsky130_fd_sc_hd__tapvpwrvgnd_1_438 VSS VDD sky130_fd_sc_hd__tapvpwrvgnd_1
* cell instance sky130_fd_sc_hd__tapvpwrvgnd_1_439 r0 *1 0,0
Xsky130_fd_sc_hd__tapvpwrvgnd_1_439 VSS VDD sky130_fd_sc_hd__tapvpwrvgnd_1
* cell instance sky130_fd_sc_hd__tapvpwrvgnd_1_440 r0 *1 0,0
Xsky130_fd_sc_hd__tapvpwrvgnd_1_440 VSS VDD sky130_fd_sc_hd__tapvpwrvgnd_1
* cell instance sky130_fd_sc_hd__tapvpwrvgnd_1_441 r0 *1 0,0
Xsky130_fd_sc_hd__tapvpwrvgnd_1_441 VSS VDD sky130_fd_sc_hd__tapvpwrvgnd_1
* cell instance sky130_fd_sc_hd__tapvpwrvgnd_1_442 r0 *1 0,0
Xsky130_fd_sc_hd__tapvpwrvgnd_1_442 VSS VDD sky130_fd_sc_hd__tapvpwrvgnd_1
* cell instance sky130_fd_sc_hd__tapvpwrvgnd_1_443 r0 *1 0,0
Xsky130_fd_sc_hd__tapvpwrvgnd_1_443 VSS VDD sky130_fd_sc_hd__tapvpwrvgnd_1
* cell instance sky130_fd_sc_hd__tapvpwrvgnd_1_444 r0 *1 0,0
Xsky130_fd_sc_hd__tapvpwrvgnd_1_444 VSS VDD sky130_fd_sc_hd__tapvpwrvgnd_1
* cell instance sky130_fd_sc_hd__tapvpwrvgnd_1_445 r0 *1 0,0
Xsky130_fd_sc_hd__tapvpwrvgnd_1_445 VSS VDD sky130_fd_sc_hd__tapvpwrvgnd_1
* cell instance sky130_fd_sc_hd__tapvpwrvgnd_1_446 r0 *1 0,0
Xsky130_fd_sc_hd__tapvpwrvgnd_1_446 VSS VDD sky130_fd_sc_hd__tapvpwrvgnd_1
* cell instance sky130_fd_sc_hd__tapvpwrvgnd_1_447 r0 *1 0,0
Xsky130_fd_sc_hd__tapvpwrvgnd_1_447 VSS VDD sky130_fd_sc_hd__tapvpwrvgnd_1
* cell instance sky130_fd_sc_hd__tapvpwrvgnd_1_448 r0 *1 0,0
Xsky130_fd_sc_hd__tapvpwrvgnd_1_448 VSS VDD sky130_fd_sc_hd__tapvpwrvgnd_1
* cell instance sky130_fd_sc_hd__tapvpwrvgnd_1_449 r0 *1 0,0
Xsky130_fd_sc_hd__tapvpwrvgnd_1_449 VSS VDD sky130_fd_sc_hd__tapvpwrvgnd_1
* cell instance sky130_fd_sc_hd__tapvpwrvgnd_1_450 r0 *1 0,0
Xsky130_fd_sc_hd__tapvpwrvgnd_1_450 VSS VDD sky130_fd_sc_hd__tapvpwrvgnd_1
* cell instance sky130_fd_sc_hd__tapvpwrvgnd_1_451 r0 *1 0,0
Xsky130_fd_sc_hd__tapvpwrvgnd_1_451 VSS VDD sky130_fd_sc_hd__tapvpwrvgnd_1
* cell instance sky130_fd_sc_hd__tapvpwrvgnd_1_452 r0 *1 0,0
Xsky130_fd_sc_hd__tapvpwrvgnd_1_452 VSS VDD sky130_fd_sc_hd__tapvpwrvgnd_1
* cell instance sky130_fd_sc_hd__tapvpwrvgnd_1_453 r0 *1 0,0
Xsky130_fd_sc_hd__tapvpwrvgnd_1_453 VSS VDD sky130_fd_sc_hd__tapvpwrvgnd_1
* cell instance sky130_fd_sc_hd__tapvpwrvgnd_1_454 r0 *1 0,0
Xsky130_fd_sc_hd__tapvpwrvgnd_1_454 VSS VDD sky130_fd_sc_hd__tapvpwrvgnd_1
* cell instance sky130_fd_sc_hd__tapvpwrvgnd_1_455 r0 *1 0,0
Xsky130_fd_sc_hd__tapvpwrvgnd_1_455 VSS VDD sky130_fd_sc_hd__tapvpwrvgnd_1
* cell instance sky130_fd_sc_hd__tapvpwrvgnd_1_456 r0 *1 0,0
Xsky130_fd_sc_hd__tapvpwrvgnd_1_456 VSS VDD sky130_fd_sc_hd__tapvpwrvgnd_1
* cell instance sky130_fd_sc_hd__tapvpwrvgnd_1_457 r0 *1 0,0
Xsky130_fd_sc_hd__tapvpwrvgnd_1_457 VSS VDD sky130_fd_sc_hd__tapvpwrvgnd_1
* cell instance sky130_fd_sc_hd__tapvpwrvgnd_1_458 r0 *1 0,0
Xsky130_fd_sc_hd__tapvpwrvgnd_1_458 VSS VDD sky130_fd_sc_hd__tapvpwrvgnd_1
* cell instance sky130_fd_sc_hd__tapvpwrvgnd_1_459 r0 *1 0,0
Xsky130_fd_sc_hd__tapvpwrvgnd_1_459 VSS VDD sky130_fd_sc_hd__tapvpwrvgnd_1
* cell instance sky130_fd_sc_hd__tapvpwrvgnd_1_460 r0 *1 0,0
Xsky130_fd_sc_hd__tapvpwrvgnd_1_460 VSS VDD sky130_fd_sc_hd__tapvpwrvgnd_1
* cell instance sky130_fd_sc_hd__tapvpwrvgnd_1_461 r0 *1 0,0
Xsky130_fd_sc_hd__tapvpwrvgnd_1_461 VSS VDD sky130_fd_sc_hd__tapvpwrvgnd_1
* cell instance sky130_fd_sc_hd__tapvpwrvgnd_1_462 r0 *1 0,0
Xsky130_fd_sc_hd__tapvpwrvgnd_1_462 VSS VDD sky130_fd_sc_hd__tapvpwrvgnd_1
* cell instance sky130_fd_sc_hd__tapvpwrvgnd_1_463 r0 *1 0,0
Xsky130_fd_sc_hd__tapvpwrvgnd_1_463 VSS VDD sky130_fd_sc_hd__tapvpwrvgnd_1
* cell instance sky130_fd_sc_hd__tapvpwrvgnd_1_464 r0 *1 0,0
Xsky130_fd_sc_hd__tapvpwrvgnd_1_464 VSS VDD sky130_fd_sc_hd__tapvpwrvgnd_1
* cell instance sky130_fd_sc_hd__tapvpwrvgnd_1_465 r0 *1 0,0
Xsky130_fd_sc_hd__tapvpwrvgnd_1_465 VSS VDD sky130_fd_sc_hd__tapvpwrvgnd_1
* cell instance sky130_fd_sc_hd__tapvpwrvgnd_1_466 r0 *1 0,0
Xsky130_fd_sc_hd__tapvpwrvgnd_1_466 VSS VDD sky130_fd_sc_hd__tapvpwrvgnd_1
* cell instance sky130_fd_sc_hd__tapvpwrvgnd_1_467 r0 *1 0,0
Xsky130_fd_sc_hd__tapvpwrvgnd_1_467 VSS VDD sky130_fd_sc_hd__tapvpwrvgnd_1
* cell instance sky130_fd_sc_hd__xnor2_1_0 r0 *1 0,0
Xsky130_fd_sc_hd__xnor2_1_0 k_q[4] \_0715_ VSS VDD VDD \_0758_
+ sky130_fd_sc_hd__xnor2_1
* cell instance sky130_fd_sc_hd__xnor2_1_1 r0 *1 0,0
Xsky130_fd_sc_hd__xnor2_1_1 gate_cnt[19] \_0303_ VSS VDD VDD \_0304_
+ sky130_fd_sc_hd__xnor2_1
* cell instance sky130_fd_sc_hd__xnor2_1_2 r0 *1 0,0
Xsky130_fd_sc_hd__xnor2_1_2 gate_cnt[9] \_0763_ VSS VDD VDD \_0764_
+ sky130_fd_sc_hd__xnor2_1
* cell instance sky130_fd_sc_hd__xnor2_1_3 r0 *1 0,0
Xsky130_fd_sc_hd__xnor2_1_3 tog_o u_cnt/_041_ VSS VDD VDD u_cnt/_013_
+ sky130_fd_sc_hd__xnor2_1
* cell instance sky130_fd_sc_hd__xnor2_1_4 r0 *1 0,0
Xsky130_fd_sc_hd__xnor2_1_4 gate_cnt[21] \_0711_ VSS VDD VDD \_0712_
+ sky130_fd_sc_hd__xnor2_1
* cell instance sky130_fd_sc_hd__xnor2_1_5 r0 *1 0,0
Xsky130_fd_sc_hd__xnor2_1_5 cnt_o[0] u_cnt/_084_ VSS VDD VDD u_cnt/_100_
+ sky130_fd_sc_hd__xnor2_1
* cell instance sky130_fd_sc_hd__xnor2_1_6 r0 *1 0,0
Xsky130_fd_sc_hd__xnor2_1_6 \_0701_ \_0706_ VSS VDD VDD \_0707_
+ sky130_fd_sc_hd__xnor2_1
* cell instance sky130_fd_sc_hd__xnor2_1_7 r0 *1 0,0
Xsky130_fd_sc_hd__xnor2_1_7 gate_cnt[0] gate_en VSS VDD VDD \_0439_
+ sky130_fd_sc_hd__xnor2_1
* cell instance sky130_fd_sc_hd__xnor2_1_8 r0 *1 0,0
Xsky130_fd_sc_hd__xnor2_1_8 gate_cnt[28] \_0742_ VSS VDD VDD \_0743_
+ sky130_fd_sc_hd__xnor2_1
* cell instance sky130_fd_sc_hd__xnor2_1_9 r0 *1 0,0
Xsky130_fd_sc_hd__xnor2_1_9 gate_cnt[14] \_0738_ VSS VDD VDD \_0739_
+ sky130_fd_sc_hd__xnor2_1
* cell instance sky130_fd_sc_hd__xnor2_1_10 r0 *1 0,0
Xsky130_fd_sc_hd__xnor2_1_10 gate_cnt[12] \_0748_ VSS VDD VDD \_0749_
+ sky130_fd_sc_hd__xnor2_1
* cell instance sky130_fd_sc_hd__xor2_1_0 r0 *1 0,0
Xsky130_fd_sc_hd__xor2_1_0 \_0467_ \_0475_ VSS VDD VDD \_0476_
+ sky130_fd_sc_hd__xor2_1
* cell instance sky130_fd_sc_hd__xor2_1_1 r0 *1 0,0
Xsky130_fd_sc_hd__xor2_1_1 gate_cnt[26] \_0724_ VSS VDD VDD \_0725_
+ sky130_fd_sc_hd__xor2_1
* cell instance sky130_fd_sc_hd__xor2_1_2 r0 *1 0,0
Xsky130_fd_sc_hd__xor2_1_2 gate_cnt[27] \_0717_ VSS VDD VDD \_0718_
+ sky130_fd_sc_hd__xor2_1
* cell instance sky130_fd_sc_hd__xor2_1_3 r0 *1 0,0
Xsky130_fd_sc_hd__xor2_1_3 gate_cnt[10] \_0726_ VSS VDD VDD \_0727_
+ sky130_fd_sc_hd__xor2_1
* cell instance sky130_fd_sc_hd__xor2_1_4 r0 *1 0,0
Xsky130_fd_sc_hd__xor2_1_4 gate_cnt[31] \_0454_ VSS VDD VDD \_0455_
+ sky130_fd_sc_hd__xor2_1
* cell instance sky130_fd_sc_hd__xor2_1_5 r0 *1 0,0
Xsky130_fd_sc_hd__xor2_1_5 gate_cnt[23] \_0733_ VSS VDD VDD \_0734_
+ sky130_fd_sc_hd__xor2_1
* cell instance sky130_fd_sc_hd__xor2_1_6 r0 *1 0,0
Xsky130_fd_sc_hd__xor2_1_6 gate_cnt[17] \_0699_ VSS VDD VDD \_0700_
+ sky130_fd_sc_hd__xor2_1
* cell instance sky130_fd_sc_hd__xor2_1_7 r0 *1 0,0
Xsky130_fd_sc_hd__xor2_1_7 gate_cnt[3] \_0307_ VSS VDD VDD \_0308_
+ sky130_fd_sc_hd__xor2_1
* cell instance sky130_fd_sc_hd__xor2_1_8 r0 *1 0,0
Xsky130_fd_sc_hd__xor2_1_8 gate_cnt[16] \_0750_ VSS VDD VDD \_0751_
+ sky130_fd_sc_hd__xor2_1
* cell instance sky130_fd_sc_hd__xor2_1_9 r0 *1 0,0
Xsky130_fd_sc_hd__xor2_1_9 gate_cnt[13] \_0708_ VSS VDD VDD \_0709_
+ sky130_fd_sc_hd__xor2_1
* cell instance sky130_fd_sc_hd__xor2_1_10 r0 *1 0,0
Xsky130_fd_sc_hd__xor2_1_10 gate_cnt[11] \_0695_ VSS VDD VDD \_0696_
+ sky130_fd_sc_hd__xor2_1
.ENDS readout

* cell sky130_fd_sc_hd__xor2_1
* pin A
* pin B
* pin VGND
* pin VPB
* pin VPWR
* pin X
.SUBCKT sky130_fd_sc_hd__xor2_1 A B VGND VPB VPWR X
.ENDS sky130_fd_sc_hd__xor2_1

* cell sky130_fd_sc_hd__xnor2_1
* pin A
* pin B
* pin VGND
* pin VPB
* pin VPWR
* pin Y
.SUBCKT sky130_fd_sc_hd__xnor2_1 A B VGND VPB VPWR Y
.ENDS sky130_fd_sc_hd__xnor2_1

* cell sky130_fd_sc_hd__tapvpwrvgnd_1
* pin VGND
* pin VPWR
.SUBCKT sky130_fd_sc_hd__tapvpwrvgnd_1 VGND VPWR
.ENDS sky130_fd_sc_hd__tapvpwrvgnd_1

* cell sky130_fd_sc_hd__or3_1
* pin A
* pin B
* pin C
* pin VGND
* pin VPB
* pin VPWR
* pin X
.SUBCKT sky130_fd_sc_hd__or3_1 A B C VGND VPB VPWR X
.ENDS sky130_fd_sc_hd__or3_1

* cell sky130_fd_sc_hd__or2_2
* pin A
* pin B
* pin VGND
* pin VPB
* pin VPWR
* pin X
.SUBCKT sky130_fd_sc_hd__or2_2 A B VGND VPB VPWR X
.ENDS sky130_fd_sc_hd__or2_2

* cell sky130_fd_sc_hd__o32a_1
* pin A1
* pin A2
* pin A3
* pin B1
* pin B2
* pin VGND
* pin VPB
* pin VPWR
* pin X
.SUBCKT sky130_fd_sc_hd__o32a_1 A1 A2 A3 B1 B2 VGND VPB VPWR X
.ENDS sky130_fd_sc_hd__o32a_1

* cell sky130_fd_sc_hd__o311ai_0
* pin A1
* pin A2
* pin A3
* pin B1
* pin C1
* pin VGND
* pin VPB
* pin VPWR
* pin Y
.SUBCKT sky130_fd_sc_hd__o311ai_0 A1 A2 A3 B1 C1 VGND VPB VPWR Y
.ENDS sky130_fd_sc_hd__o311ai_0

* cell sky130_fd_sc_hd__o22ai_1
* pin A1
* pin A2
* pin B1
* pin B2
* pin VGND
* pin VPB
* pin VPWR
* pin Y
.SUBCKT sky130_fd_sc_hd__o22ai_1 A1 A2 B1 B2 VGND VPB VPWR Y
.ENDS sky130_fd_sc_hd__o22ai_1

* cell sky130_fd_sc_hd__o221ai_1
* pin A1
* pin A2
* pin B1
* pin B2
* pin C1
* pin VGND
* pin VPB
* pin VPWR
* pin Y
.SUBCKT sky130_fd_sc_hd__o221ai_1 A1 A2 B1 B2 C1 VGND VPB VPWR Y
.ENDS sky130_fd_sc_hd__o221ai_1

* cell sky130_fd_sc_hd__o21bai_1
* pin A1
* pin A2
* pin B1_N
* pin VGND
* pin VPB
* pin VPWR
* pin Y
.SUBCKT sky130_fd_sc_hd__o21bai_1 A1 A2 B1_N VGND VPB VPWR Y
.ENDS sky130_fd_sc_hd__o21bai_1

* cell sky130_fd_sc_hd__o21ai_1
* pin A1
* pin A2
* pin B1
* pin VGND
* pin VPB
* pin VPWR
* pin Y
.SUBCKT sky130_fd_sc_hd__o21ai_1 A1 A2 B1 VGND VPB VPWR Y
.ENDS sky130_fd_sc_hd__o21ai_1

* cell sky130_fd_sc_hd__o21ai_0
* pin A1
* pin A2
* pin B1
* pin VGND
* pin VPB
* pin VPWR
* pin Y
.SUBCKT sky130_fd_sc_hd__o21ai_0 A1 A2 B1 VGND VPB VPWR Y
.ENDS sky130_fd_sc_hd__o21ai_0

* cell sky130_fd_sc_hd__o21a_1
* pin A1
* pin A2
* pin B1
* pin VGND
* pin VPB
* pin VPWR
* pin X
.SUBCKT sky130_fd_sc_hd__o21a_1 A1 A2 B1 VGND VPB VPWR X
.ENDS sky130_fd_sc_hd__o21a_1

* cell sky130_fd_sc_hd__o211ai_1
* pin A1
* pin A2
* pin B1
* pin C1
* pin VGND
* pin VPB
* pin VPWR
* pin Y
.SUBCKT sky130_fd_sc_hd__o211ai_1 A1 A2 B1 C1 VGND VPB VPWR Y
.ENDS sky130_fd_sc_hd__o211ai_1

* cell sky130_fd_sc_hd__o2111ai_1
* pin A1
* pin A2
* pin B1
* pin C1
* pin D1
* pin VGND
* pin VPB
* pin VPWR
* pin Y
.SUBCKT sky130_fd_sc_hd__o2111ai_1 A1 A2 B1 C1 D1 VGND VPB VPWR Y
.ENDS sky130_fd_sc_hd__o2111ai_1

* cell sky130_fd_sc_hd__nor4bb_1
* pin A
* pin B
* pin C_N
* pin D_N
* pin VGND
* pin VPB
* pin VPWR
* pin Y
.SUBCKT sky130_fd_sc_hd__nor4bb_1 A B C_N D_N VGND VPB VPWR Y
.ENDS sky130_fd_sc_hd__nor4bb_1

* cell sky130_fd_sc_hd__nor4_4
* pin A
* pin B
* pin C
* pin D
* pin VGND
* pin VPB
* pin VPWR
* pin Y
.SUBCKT sky130_fd_sc_hd__nor4_4 A B C D VGND VPB VPWR Y
.ENDS sky130_fd_sc_hd__nor4_4

* cell sky130_fd_sc_hd__nor4_1
* pin A
* pin B
* pin C
* pin D
* pin VGND
* pin VPB
* pin VPWR
* pin Y
.SUBCKT sky130_fd_sc_hd__nor4_1 A B C D VGND VPB VPWR Y
.ENDS sky130_fd_sc_hd__nor4_1

* cell sky130_fd_sc_hd__nor3b_1
* pin A
* pin B
* pin C_N
* pin VGND
* pin VPB
* pin VPWR
* pin Y
.SUBCKT sky130_fd_sc_hd__nor3b_1 A B C_N VGND VPB VPWR Y
.ENDS sky130_fd_sc_hd__nor3b_1

* cell sky130_fd_sc_hd__nor3_2
* pin A
* pin B
* pin C
* pin VGND
* pin VPB
* pin VPWR
* pin Y
.SUBCKT sky130_fd_sc_hd__nor3_2 A B C VGND VPB VPWR Y
.ENDS sky130_fd_sc_hd__nor3_2

* cell sky130_fd_sc_hd__nor3_1
* pin A
* pin B
* pin C
* pin VGND
* pin VPB
* pin VPWR
* pin Y
.SUBCKT sky130_fd_sc_hd__nor3_1 A B C VGND VPB VPWR Y
.ENDS sky130_fd_sc_hd__nor3_1

* cell sky130_fd_sc_hd__nor2b_1
* pin A
* pin B_N
* pin VGND
* pin VPB
* pin VPWR
* pin Y
.SUBCKT sky130_fd_sc_hd__nor2b_1 A B_N VGND VPB VPWR Y
.ENDS sky130_fd_sc_hd__nor2b_1

* cell sky130_fd_sc_hd__nor2_4
* pin A
* pin B
* pin VGND
* pin VPB
* pin VPWR
* pin Y
.SUBCKT sky130_fd_sc_hd__nor2_4 A B VGND VPB VPWR Y
.ENDS sky130_fd_sc_hd__nor2_4

* cell sky130_fd_sc_hd__nor2_1
* pin A
* pin B
* pin VGND
* pin VPB
* pin VPWR
* pin Y
.SUBCKT sky130_fd_sc_hd__nor2_1 A B VGND VPB VPWR Y
.ENDS sky130_fd_sc_hd__nor2_1

* cell sky130_fd_sc_hd__nand4bb_1
* pin A_N
* pin B_N
* pin C
* pin D
* pin VGND
* pin VPB
* pin VPWR
* pin Y
.SUBCKT sky130_fd_sc_hd__nand4bb_1 A_N B_N C D VGND VPB VPWR Y
.ENDS sky130_fd_sc_hd__nand4bb_1

* cell sky130_fd_sc_hd__nand4b_1
* pin A_N
* pin B
* pin C
* pin D
* pin VGND
* pin VPB
* pin VPWR
* pin Y
.SUBCKT sky130_fd_sc_hd__nand4b_1 A_N B C D VGND VPB VPWR Y
.ENDS sky130_fd_sc_hd__nand4b_1

* cell sky130_fd_sc_hd__nand4_2
* pin A
* pin B
* pin C
* pin D
* pin VGND
* pin VPB
* pin VPWR
* pin Y
.SUBCKT sky130_fd_sc_hd__nand4_2 A B C D VGND VPB VPWR Y
.ENDS sky130_fd_sc_hd__nand4_2

* cell sky130_fd_sc_hd__nand4_1
* pin A
* pin B
* pin C
* pin D
* pin VGND
* pin VPB
* pin VPWR
* pin Y
.SUBCKT sky130_fd_sc_hd__nand4_1 A B C D VGND VPB VPWR Y
.ENDS sky130_fd_sc_hd__nand4_1

* cell sky130_fd_sc_hd__nand3_2
* pin A
* pin B
* pin C
* pin VGND
* pin VPB
* pin VPWR
* pin Y
.SUBCKT sky130_fd_sc_hd__nand3_2 A B C VGND VPB VPWR Y
.ENDS sky130_fd_sc_hd__nand3_2

* cell sky130_fd_sc_hd__nand3_1
* pin A
* pin B
* pin C
* pin VGND
* pin VPB
* pin VPWR
* pin Y
.SUBCKT sky130_fd_sc_hd__nand3_1 A B C VGND VPB VPWR Y
.ENDS sky130_fd_sc_hd__nand3_1

* cell sky130_fd_sc_hd__nand2b_1
* pin A_N
* pin B
* pin VGND
* pin VPB
* pin VPWR
* pin Y
.SUBCKT sky130_fd_sc_hd__nand2b_1 A_N B VGND VPB VPWR Y
.ENDS sky130_fd_sc_hd__nand2b_1

* cell sky130_fd_sc_hd__nand2_2
* pin A
* pin B
* pin VGND
* pin VPB
* pin VPWR
* pin Y
.SUBCKT sky130_fd_sc_hd__nand2_2 A B VGND VPB VPWR Y
.ENDS sky130_fd_sc_hd__nand2_2

* cell sky130_fd_sc_hd__nand2_1
* pin A
* pin B
* pin VGND
* pin VPB
* pin VPWR
* pin Y
.SUBCKT sky130_fd_sc_hd__nand2_1 A B VGND VPB VPWR Y
.ENDS sky130_fd_sc_hd__nand2_1

* cell sky130_fd_sc_hd__mux2_2
* pin A0
* pin A1
* pin S
* pin VGND
* pin VPB
* pin VPWR
* pin X
.SUBCKT sky130_fd_sc_hd__mux2_2 A0 A1 S VGND VPB VPWR X
.ENDS sky130_fd_sc_hd__mux2_2

* cell sky130_fd_sc_hd__inv_1
* pin A
* pin VGND
* pin VPB
* pin VPWR
* pin Y
.SUBCKT sky130_fd_sc_hd__inv_1 A VGND VPB VPWR Y
.ENDS sky130_fd_sc_hd__inv_1

* cell sky130_fd_sc_hd__fill_8
* pin VGND
* pin VPB
* pin VPWR
.SUBCKT sky130_fd_sc_hd__fill_8 VGND VPB VPWR
.ENDS sky130_fd_sc_hd__fill_8

* cell sky130_fd_sc_hd__fill_4
* pin VGND
* pin VPB
* pin VPWR
.SUBCKT sky130_fd_sc_hd__fill_4 VGND VPB VPWR
.ENDS sky130_fd_sc_hd__fill_4

* cell sky130_fd_sc_hd__fill_2
* pin VGND
* pin VPB
* pin VPWR
.SUBCKT sky130_fd_sc_hd__fill_2 VGND VPB VPWR
.ENDS sky130_fd_sc_hd__fill_2

* cell sky130_fd_sc_hd__fill_1
* pin VGND
* pin VPB
* pin VPWR
.SUBCKT sky130_fd_sc_hd__fill_1 VGND VPB VPWR
.ENDS sky130_fd_sc_hd__fill_1

* cell sky130_fd_sc_hd__diode_2
* pin DIODE
* pin VGND
* pin VPB
* pin VPWR
.SUBCKT sky130_fd_sc_hd__diode_2 DIODE VGND VPB VPWR
.ENDS sky130_fd_sc_hd__diode_2

* cell sky130_fd_sc_hd__dfstp_2
* pin CLK
* pin D
* pin Q
* pin SET_B
* pin VGND
* pin VPB
* pin VPWR
.SUBCKT sky130_fd_sc_hd__dfstp_2 CLK D Q SET_B VGND VPB VPWR
.ENDS sky130_fd_sc_hd__dfstp_2

* cell sky130_fd_sc_hd__dfrtp_1
* pin CLK
* pin D
* pin Q
* pin RESET_B
* pin VGND
* pin VPB
* pin VPWR
.SUBCKT sky130_fd_sc_hd__dfrtp_1 CLK D Q RESET_B VGND VPB VPWR
.ENDS sky130_fd_sc_hd__dfrtp_1

* cell sky130_fd_sc_hd__conb_1
* pin HI
* pin LO
* pin VGND
* pin VPB
* pin VPWR
.SUBCKT sky130_fd_sc_hd__conb_1 HI LO VGND VPB VPWR
.ENDS sky130_fd_sc_hd__conb_1

* cell sky130_fd_sc_hd__clkinvlp_2
* pin A
* pin VGND
* pin VPB
* pin VPWR
* pin Y
.SUBCKT sky130_fd_sc_hd__clkinvlp_2 A VGND VPB VPWR Y
.ENDS sky130_fd_sc_hd__clkinvlp_2

* cell sky130_fd_sc_hd__clkinv_1
* pin A
* pin VGND
* pin VPB
* pin VPWR
* pin Y
.SUBCKT sky130_fd_sc_hd__clkinv_1 A VGND VPB VPWR Y
.ENDS sky130_fd_sc_hd__clkinv_1

* cell sky130_fd_sc_hd__clkbuf_1
* pin A
* pin VGND
* pin VPB
* pin VPWR
* pin X
.SUBCKT sky130_fd_sc_hd__clkbuf_1 A VGND VPB VPWR X
.ENDS sky130_fd_sc_hd__clkbuf_1

* cell sky130_fd_sc_hd__bufinv_16
* pin A
* pin VGND
* pin VPB
* pin VPWR
* pin Y
.SUBCKT sky130_fd_sc_hd__bufinv_16 A VGND VPB VPWR Y
.ENDS sky130_fd_sc_hd__bufinv_16

* cell sky130_fd_sc_hd__buf_4
* pin A
* pin VGND
* pin VPB
* pin VPWR
* pin X
.SUBCKT sky130_fd_sc_hd__buf_4 A VGND VPB VPWR X
.ENDS sky130_fd_sc_hd__buf_4

* cell sky130_fd_sc_hd__buf_2
* pin A
* pin VGND
* pin VPB
* pin VPWR
* pin X
.SUBCKT sky130_fd_sc_hd__buf_2 A VGND VPB VPWR X
.ENDS sky130_fd_sc_hd__buf_2

* cell sky130_fd_sc_hd__and4b_1
* pin A_N
* pin B
* pin C
* pin D
* pin VGND
* pin VPB
* pin VPWR
* pin X
.SUBCKT sky130_fd_sc_hd__and4b_1 A_N B C D VGND VPB VPWR X
.ENDS sky130_fd_sc_hd__and4b_1

* cell sky130_fd_sc_hd__and4_4
* pin A
* pin B
* pin C
* pin D
* pin VGND
* pin VPB
* pin VPWR
* pin X
.SUBCKT sky130_fd_sc_hd__and4_4 A B C D VGND VPB VPWR X
.ENDS sky130_fd_sc_hd__and4_4

* cell sky130_fd_sc_hd__and4_1
* pin A
* pin B
* pin C
* pin D
* pin VGND
* pin VPB
* pin VPWR
* pin X
.SUBCKT sky130_fd_sc_hd__and4_1 A B C D VGND VPB VPWR X
.ENDS sky130_fd_sc_hd__and4_1

* cell sky130_fd_sc_hd__and3b_1
* pin A_N
* pin B
* pin C
* pin VGND
* pin VPB
* pin VPWR
* pin X
.SUBCKT sky130_fd_sc_hd__and3b_1 A_N B C VGND VPB VPWR X
.ENDS sky130_fd_sc_hd__and3b_1

* cell sky130_fd_sc_hd__and3_4
* pin A
* pin B
* pin C
* pin VGND
* pin VPB
* pin VPWR
* pin X
.SUBCKT sky130_fd_sc_hd__and3_4 A B C VGND VPB VPWR X
.ENDS sky130_fd_sc_hd__and3_4

* cell sky130_fd_sc_hd__and3_2
* pin A
* pin B
* pin C
* pin VGND
* pin VPB
* pin VPWR
* pin X
.SUBCKT sky130_fd_sc_hd__and3_2 A B C VGND VPB VPWR X
.ENDS sky130_fd_sc_hd__and3_2

* cell sky130_fd_sc_hd__and3_1
* pin A
* pin B
* pin C
* pin VGND
* pin VPB
* pin VPWR
* pin X
.SUBCKT sky130_fd_sc_hd__and3_1 A B C VGND VPB VPWR X
.ENDS sky130_fd_sc_hd__and3_1

* cell sky130_fd_sc_hd__and2_2
* pin A
* pin B
* pin VGND
* pin VPB
* pin VPWR
* pin X
.SUBCKT sky130_fd_sc_hd__and2_2 A B VGND VPB VPWR X
.ENDS sky130_fd_sc_hd__and2_2

* cell sky130_fd_sc_hd__and2_1
* pin A
* pin B
* pin VGND
* pin VPB
* pin VPWR
* pin X
.SUBCKT sky130_fd_sc_hd__and2_1 A B VGND VPB VPWR X
.ENDS sky130_fd_sc_hd__and2_1

* cell sky130_fd_sc_hd__a41oi_2
* pin A1
* pin A2
* pin A3
* pin A4
* pin B1
* pin VGND
* pin VPB
* pin VPWR
* pin Y
.SUBCKT sky130_fd_sc_hd__a41oi_2 A1 A2 A3 A4 B1 VGND VPB VPWR Y
.ENDS sky130_fd_sc_hd__a41oi_2

* cell sky130_fd_sc_hd__a41oi_1
* pin A1
* pin A2
* pin A3
* pin A4
* pin B1
* pin VGND
* pin VPB
* pin VPWR
* pin Y
.SUBCKT sky130_fd_sc_hd__a41oi_1 A1 A2 A3 A4 B1 VGND VPB VPWR Y
.ENDS sky130_fd_sc_hd__a41oi_1

* cell sky130_fd_sc_hd__a41o_1
* pin A1
* pin A2
* pin A3
* pin A4
* pin B1
* pin VGND
* pin VPB
* pin VPWR
* pin X
.SUBCKT sky130_fd_sc_hd__a41o_1 A1 A2 A3 A4 B1 VGND VPB VPWR X
.ENDS sky130_fd_sc_hd__a41o_1

* cell sky130_fd_sc_hd__a32oi_1
* pin A1
* pin A2
* pin A3
* pin B1
* pin B2
* pin VGND
* pin VPB
* pin VPWR
* pin Y
.SUBCKT sky130_fd_sc_hd__a32oi_1 A1 A2 A3 B1 B2 VGND VPB VPWR Y
.ENDS sky130_fd_sc_hd__a32oi_1

* cell sky130_fd_sc_hd__a31oi_1
* pin A1
* pin A2
* pin A3
* pin B1
* pin VGND
* pin VPB
* pin VPWR
* pin Y
.SUBCKT sky130_fd_sc_hd__a31oi_1 A1 A2 A3 B1 VGND VPB VPWR Y
.ENDS sky130_fd_sc_hd__a31oi_1

* cell sky130_fd_sc_hd__a31o_1
* pin A1
* pin A2
* pin A3
* pin B1
* pin VGND
* pin VPB
* pin VPWR
* pin X
.SUBCKT sky130_fd_sc_hd__a31o_1 A1 A2 A3 B1 VGND VPB VPWR X
.ENDS sky130_fd_sc_hd__a31o_1

* cell sky130_fd_sc_hd__a311oi_1
* pin A1
* pin A2
* pin A3
* pin B1
* pin C1
* pin VGND
* pin VPB
* pin VPWR
* pin Y
.SUBCKT sky130_fd_sc_hd__a311oi_1 A1 A2 A3 B1 C1 VGND VPB VPWR Y
.ENDS sky130_fd_sc_hd__a311oi_1

* cell sky130_fd_sc_hd__a22oi_1
* pin A1
* pin A2
* pin B1
* pin B2
* pin VGND
* pin VPB
* pin VPWR
* pin Y
.SUBCKT sky130_fd_sc_hd__a22oi_1 A1 A2 B1 B2 VGND VPB VPWR Y
.ENDS sky130_fd_sc_hd__a22oi_1

* cell sky130_fd_sc_hd__a222oi_1
* pin A1
* pin A2
* pin B1
* pin B2
* pin C1
* pin C2
* pin VGND
* pin VPB
* pin VPWR
* pin Y
.SUBCKT sky130_fd_sc_hd__a222oi_1 A1 A2 B1 B2 C1 C2 VGND VPB VPWR Y
.ENDS sky130_fd_sc_hd__a222oi_1

* cell sky130_fd_sc_hd__a221oi_1
* pin A1
* pin A2
* pin B1
* pin B2
* pin C1
* pin VGND
* pin VPB
* pin VPWR
* pin Y
.SUBCKT sky130_fd_sc_hd__a221oi_1 A1 A2 B1 B2 C1 VGND VPB VPWR Y
.ENDS sky130_fd_sc_hd__a221oi_1

* cell sky130_fd_sc_hd__a221o_1
* pin A1
* pin A2
* pin B1
* pin B2
* pin C1
* pin VGND
* pin VPB
* pin VPWR
* pin X
.SUBCKT sky130_fd_sc_hd__a221o_1 A1 A2 B1 B2 C1 VGND VPB VPWR X
.ENDS sky130_fd_sc_hd__a221o_1

* cell sky130_fd_sc_hd__a21oi_1
* pin A1
* pin A2
* pin B1
* pin VGND
* pin VPB
* pin VPWR
* pin Y
.SUBCKT sky130_fd_sc_hd__a21oi_1 A1 A2 B1 VGND VPB VPWR Y
.ENDS sky130_fd_sc_hd__a21oi_1

* cell sky130_fd_sc_hd__a21o_1
* pin A1
* pin A2
* pin B1
* pin VGND
* pin VPB
* pin VPWR
* pin X
.SUBCKT sky130_fd_sc_hd__a21o_1 A1 A2 B1 VGND VPB VPWR X
.ENDS sky130_fd_sc_hd__a21o_1

* cell sky130_fd_sc_hd__a21boi_0
* pin A1
* pin A2
* pin B1_N
* pin VGND
* pin VPB
* pin VPWR
* pin Y
.SUBCKT sky130_fd_sc_hd__a21boi_0 A1 A2 B1_N VGND VPB VPWR Y
.ENDS sky130_fd_sc_hd__a21boi_0

* cell sky130_fd_sc_hd__a211oi_2
* pin A1
* pin A2
* pin B1
* pin C1
* pin VGND
* pin VPB
* pin VPWR
* pin Y
.SUBCKT sky130_fd_sc_hd__a211oi_2 A1 A2 B1 C1 VGND VPB VPWR Y
.ENDS sky130_fd_sc_hd__a211oi_2

* cell sky130_fd_sc_hd__a211oi_1
* pin A1
* pin A2
* pin B1
* pin C1
* pin VGND
* pin VPB
* pin VPWR
* pin Y
.SUBCKT sky130_fd_sc_hd__a211oi_1 A1 A2 B1 C1 VGND VPB VPWR Y
.ENDS sky130_fd_sc_hd__a211oi_1

* cell sky130_fd_sc_hd__a211o_1
* pin A1
* pin A2
* pin B1
* pin C1
* pin VGND
* pin VPB
* pin VPWR
* pin X
.SUBCKT sky130_fd_sc_hd__a211o_1 A1 A2 B1 C1 VGND VPB VPWR X
.ENDS sky130_fd_sc_hd__a211o_1

* cell sky130_fd_sc_hd__a2111oi_0
* pin A1
* pin A2
* pin B1
* pin C1
* pin D1
* pin VGND
* pin VPB
* pin VPWR
* pin Y
.SUBCKT sky130_fd_sc_hd__a2111oi_0 A1 A2 B1 C1 D1 VGND VPB VPWR Y
.ENDS sky130_fd_sc_hd__a2111oi_0

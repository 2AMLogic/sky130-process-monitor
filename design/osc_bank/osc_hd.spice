** sch_path: /home/ubuntu/GitHub/sky130-process-monitor/.loom/worktrees/issue-17/design/osc_bank/osc_hd.sch
.subckt osc_hd en out vdd vss
*.ipin en
*.opin out
*.iopin vdd
*.iopin vss
x0 out en vss vss vdd vdd n0 sky130_fd_sc_hd__nand2_1
x1 n0 vss vss vdd vdd n1 sky130_fd_sc_hd__inv_1
x2 n1 vss vss vdd vdd n2 sky130_fd_sc_hd__inv_1
x3 n2 vss vss vdd vdd n3 sky130_fd_sc_hd__inv_1
x4 n3 vss vss vdd vdd n4 sky130_fd_sc_hd__inv_1
x5 n4 vss vss vdd vdd n5 sky130_fd_sc_hd__inv_1
x6 n5 vss vss vdd vdd n6 sky130_fd_sc_hd__inv_1
x7 n6 vss vss vdd vdd n7 sky130_fd_sc_hd__inv_1
x8 n7 vss vss vdd vdd n8 sky130_fd_sc_hd__inv_1
x9 n8 vss vss vdd vdd n9 sky130_fd_sc_hd__inv_1
x10 n9 vss vss vdd vdd n10 sky130_fd_sc_hd__inv_1
x11 n10 vss vss vdd vdd n11 sky130_fd_sc_hd__inv_1
x12 n11 vss vss vdd vdd n12 sky130_fd_sc_hd__inv_1
x13 n12 vss vss vdd vdd n13 sky130_fd_sc_hd__inv_1
x14 n13 vss vss vdd vdd n14 sky130_fd_sc_hd__inv_1
x15 n14 vss vss vdd vdd n15 sky130_fd_sc_hd__inv_1
x16 n15 vss vss vdd vdd n16 sky130_fd_sc_hd__inv_1
x17 n16 vss vss vdd vdd n17 sky130_fd_sc_hd__inv_1
x18 n17 vss vss vdd vdd n18 sky130_fd_sc_hd__inv_1
x19 n18 vss vss vdd vdd n19 sky130_fd_sc_hd__inv_1
x20 n19 vss vss vdd vdd n20 sky130_fd_sc_hd__inv_1
x21 n20 vss vss vdd vdd n21 sky130_fd_sc_hd__inv_1
x22 n21 vss vss vdd vdd n22 sky130_fd_sc_hd__inv_1
x23 n22 vss vss vdd vdd n23 sky130_fd_sc_hd__inv_1
x24 n23 vss vss vdd vdd n24 sky130_fd_sc_hd__inv_1
x25 n24 vss vss vdd vdd n25 sky130_fd_sc_hd__inv_1
x26 n25 vss vss vdd vdd n26 sky130_fd_sc_hd__inv_1
x27 n26 vss vss vdd vdd n27 sky130_fd_sc_hd__inv_1
x28 n27 vss vss vdd vdd n28 sky130_fd_sc_hd__inv_1
x29 n28 vss vss vdd vdd n29 sky130_fd_sc_hd__inv_1
x30 n29 vss vss vdd vdd out sky130_fd_sc_hd__inv_1
.ends

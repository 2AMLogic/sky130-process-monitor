** sch_path: /home/ubuntu/GitHub/sky130-process-monitor/.loom/worktrees/issue-17/design/osc_bank/osc_pmos.sch
.subckt osc_pmos en out vdd vss
*.ipin en
*.opin out
*.iopin vdd
*.iopin vss
XMp1 n0 out vdd vdd sky130_fd_pr__pfet_01v8 L=0.5 W=0.42 nf=1 ad=0.1218 as=0.1218 pd=1.42 ps=1.42 nrd=0.69047619047619
+ nrs=0.69047619047619 sa=0 sb=0 sd=0 mult=1 m=1
XMp6 n0 en vdd vdd sky130_fd_pr__pfet_01v8 L=0.5 W=0.42 nf=1 ad=0.1218 as=0.1218 pd=1.42 ps=1.42 nrd=0.69047619047619
+ nrs=0.69047619047619 sa=0 sb=0 sd=0 mult=1 m=1
XMn11 n0 out mid vss sky130_fd_pr__nfet_01v8 L=0.15 W=6.0 nf=1 ad=1.74 as=1.74 pd=12.58 ps=12.58 nrd=0.0483333333333333
+ nrs=0.0483333333333333 sa=0 sb=0 sd=0 mult=1 m=1
XMn16 mid en vss vss sky130_fd_pr__nfet_01v8 L=0.15 W=6.0 nf=1 ad=1.74 as=1.74 pd=12.58 ps=12.58 nrd=0.0483333333333333
+ nrs=0.0483333333333333 sa=0 sb=0 sd=0 mult=1 m=1
XMp21 n1 n0 vdd vdd sky130_fd_pr__pfet_01v8 L=0.5 W=0.42 nf=1 ad=0.1218 as=0.1218 pd=1.42 ps=1.42 nrd=0.69047619047619
+ nrs=0.69047619047619 sa=0 sb=0 sd=0 mult=1 m=1
XMn26 n1 n0 vss vss sky130_fd_pr__nfet_01v8 L=0.15 W=3.0 nf=1 ad=0.87 as=0.87 pd=6.58 ps=6.58 nrd=0.0966666666666667
+ nrs=0.0966666666666667 sa=0 sb=0 sd=0 mult=1 m=1
XMp31 n2 n1 vdd vdd sky130_fd_pr__pfet_01v8 L=0.5 W=0.42 nf=1 ad=0.1218 as=0.1218 pd=1.42 ps=1.42 nrd=0.69047619047619
+ nrs=0.69047619047619 sa=0 sb=0 sd=0 mult=1 m=1
XMn36 n2 n1 vss vss sky130_fd_pr__nfet_01v8 L=0.15 W=3.0 nf=1 ad=0.87 as=0.87 pd=6.58 ps=6.58 nrd=0.0966666666666667
+ nrs=0.0966666666666667 sa=0 sb=0 sd=0 mult=1 m=1
XMp41 n3 n2 vdd vdd sky130_fd_pr__pfet_01v8 L=0.5 W=0.42 nf=1 ad=0.1218 as=0.1218 pd=1.42 ps=1.42 nrd=0.69047619047619
+ nrs=0.69047619047619 sa=0 sb=0 sd=0 mult=1 m=1
XMn46 n3 n2 vss vss sky130_fd_pr__nfet_01v8 L=0.15 W=3.0 nf=1 ad=0.87 as=0.87 pd=6.58 ps=6.58 nrd=0.0966666666666667
+ nrs=0.0966666666666667 sa=0 sb=0 sd=0 mult=1 m=1
XMp51 n4 n3 vdd vdd sky130_fd_pr__pfet_01v8 L=0.5 W=0.42 nf=1 ad=0.1218 as=0.1218 pd=1.42 ps=1.42 nrd=0.69047619047619
+ nrs=0.69047619047619 sa=0 sb=0 sd=0 mult=1 m=1
XMn56 n4 n3 vss vss sky130_fd_pr__nfet_01v8 L=0.15 W=3.0 nf=1 ad=0.87 as=0.87 pd=6.58 ps=6.58 nrd=0.0966666666666667
+ nrs=0.0966666666666667 sa=0 sb=0 sd=0 mult=1 m=1
XMp61 n5 n4 vdd vdd sky130_fd_pr__pfet_01v8 L=0.5 W=0.42 nf=1 ad=0.1218 as=0.1218 pd=1.42 ps=1.42 nrd=0.69047619047619
+ nrs=0.69047619047619 sa=0 sb=0 sd=0 mult=1 m=1
XMn66 n5 n4 vss vss sky130_fd_pr__nfet_01v8 L=0.15 W=3.0 nf=1 ad=0.87 as=0.87 pd=6.58 ps=6.58 nrd=0.0966666666666667
+ nrs=0.0966666666666667 sa=0 sb=0 sd=0 mult=1 m=1
XMp71 n6 n5 vdd vdd sky130_fd_pr__pfet_01v8 L=0.5 W=0.42 nf=1 ad=0.1218 as=0.1218 pd=1.42 ps=1.42 nrd=0.69047619047619
+ nrs=0.69047619047619 sa=0 sb=0 sd=0 mult=1 m=1
XMn76 n6 n5 vss vss sky130_fd_pr__nfet_01v8 L=0.15 W=3.0 nf=1 ad=0.87 as=0.87 pd=6.58 ps=6.58 nrd=0.0966666666666667
+ nrs=0.0966666666666667 sa=0 sb=0 sd=0 mult=1 m=1
XMp81 n7 n6 vdd vdd sky130_fd_pr__pfet_01v8 L=0.5 W=0.42 nf=1 ad=0.1218 as=0.1218 pd=1.42 ps=1.42 nrd=0.69047619047619
+ nrs=0.69047619047619 sa=0 sb=0 sd=0 mult=1 m=1
XMn86 n7 n6 vss vss sky130_fd_pr__nfet_01v8 L=0.15 W=3.0 nf=1 ad=0.87 as=0.87 pd=6.58 ps=6.58 nrd=0.0966666666666667
+ nrs=0.0966666666666667 sa=0 sb=0 sd=0 mult=1 m=1
XMp91 n8 n7 vdd vdd sky130_fd_pr__pfet_01v8 L=0.5 W=0.42 nf=1 ad=0.1218 as=0.1218 pd=1.42 ps=1.42 nrd=0.69047619047619
+ nrs=0.69047619047619 sa=0 sb=0 sd=0 mult=1 m=1
XMn96 n8 n7 vss vss sky130_fd_pr__nfet_01v8 L=0.15 W=3.0 nf=1 ad=0.87 as=0.87 pd=6.58 ps=6.58 nrd=0.0966666666666667
+ nrs=0.0966666666666667 sa=0 sb=0 sd=0 mult=1 m=1
XMp101 n9 n8 vdd vdd sky130_fd_pr__pfet_01v8 L=0.5 W=0.42 nf=1 ad=0.1218 as=0.1218 pd=1.42 ps=1.42 nrd=0.69047619047619
+ nrs=0.69047619047619 sa=0 sb=0 sd=0 mult=1 m=1
XMn106 n9 n8 vss vss sky130_fd_pr__nfet_01v8 L=0.15 W=3.0 nf=1 ad=0.87 as=0.87 pd=6.58 ps=6.58 nrd=0.0966666666666667
+ nrs=0.0966666666666667 sa=0 sb=0 sd=0 mult=1 m=1
XMp111 n10 n9 vdd vdd sky130_fd_pr__pfet_01v8 L=0.5 W=0.42 nf=1 ad=0.1218 as=0.1218 pd=1.42 ps=1.42 nrd=0.69047619047619
+ nrs=0.69047619047619 sa=0 sb=0 sd=0 mult=1 m=1
XMn116 n10 n9 vss vss sky130_fd_pr__nfet_01v8 L=0.15 W=3.0 nf=1 ad=0.87 as=0.87 pd=6.58 ps=6.58 nrd=0.0966666666666667
+ nrs=0.0966666666666667 sa=0 sb=0 sd=0 mult=1 m=1
XMp121 n11 n10 vdd vdd sky130_fd_pr__pfet_01v8 L=0.5 W=0.42 nf=1 ad=0.1218 as=0.1218 pd=1.42 ps=1.42 nrd=0.69047619047619
+ nrs=0.69047619047619 sa=0 sb=0 sd=0 mult=1 m=1
XMn126 n11 n10 vss vss sky130_fd_pr__nfet_01v8 L=0.15 W=3.0 nf=1 ad=0.87 as=0.87 pd=6.58 ps=6.58 nrd=0.0966666666666667
+ nrs=0.0966666666666667 sa=0 sb=0 sd=0 mult=1 m=1
XMp131 n12 n11 vdd vdd sky130_fd_pr__pfet_01v8 L=0.5 W=0.42 nf=1 ad=0.1218 as=0.1218 pd=1.42 ps=1.42 nrd=0.69047619047619
+ nrs=0.69047619047619 sa=0 sb=0 sd=0 mult=1 m=1
XMn136 n12 n11 vss vss sky130_fd_pr__nfet_01v8 L=0.15 W=3.0 nf=1 ad=0.87 as=0.87 pd=6.58 ps=6.58 nrd=0.0966666666666667
+ nrs=0.0966666666666667 sa=0 sb=0 sd=0 mult=1 m=1
XMp141 n13 n12 vdd vdd sky130_fd_pr__pfet_01v8 L=0.5 W=0.42 nf=1 ad=0.1218 as=0.1218 pd=1.42 ps=1.42 nrd=0.69047619047619
+ nrs=0.69047619047619 sa=0 sb=0 sd=0 mult=1 m=1
XMn146 n13 n12 vss vss sky130_fd_pr__nfet_01v8 L=0.15 W=3.0 nf=1 ad=0.87 as=0.87 pd=6.58 ps=6.58 nrd=0.0966666666666667
+ nrs=0.0966666666666667 sa=0 sb=0 sd=0 mult=1 m=1
XMp151 n14 n13 vdd vdd sky130_fd_pr__pfet_01v8 L=0.5 W=0.42 nf=1 ad=0.1218 as=0.1218 pd=1.42 ps=1.42 nrd=0.69047619047619
+ nrs=0.69047619047619 sa=0 sb=0 sd=0 mult=1 m=1
XMn156 n14 n13 vss vss sky130_fd_pr__nfet_01v8 L=0.15 W=3.0 nf=1 ad=0.87 as=0.87 pd=6.58 ps=6.58 nrd=0.0966666666666667
+ nrs=0.0966666666666667 sa=0 sb=0 sd=0 mult=1 m=1
XMp161 n15 n14 vdd vdd sky130_fd_pr__pfet_01v8 L=0.5 W=0.42 nf=1 ad=0.1218 as=0.1218 pd=1.42 ps=1.42 nrd=0.69047619047619
+ nrs=0.69047619047619 sa=0 sb=0 sd=0 mult=1 m=1
XMn166 n15 n14 vss vss sky130_fd_pr__nfet_01v8 L=0.15 W=3.0 nf=1 ad=0.87 as=0.87 pd=6.58 ps=6.58 nrd=0.0966666666666667
+ nrs=0.0966666666666667 sa=0 sb=0 sd=0 mult=1 m=1
XMp171 n16 n15 vdd vdd sky130_fd_pr__pfet_01v8 L=0.5 W=0.42 nf=1 ad=0.1218 as=0.1218 pd=1.42 ps=1.42 nrd=0.69047619047619
+ nrs=0.69047619047619 sa=0 sb=0 sd=0 mult=1 m=1
XMn176 n16 n15 vss vss sky130_fd_pr__nfet_01v8 L=0.15 W=3.0 nf=1 ad=0.87 as=0.87 pd=6.58 ps=6.58 nrd=0.0966666666666667
+ nrs=0.0966666666666667 sa=0 sb=0 sd=0 mult=1 m=1
XMp181 n17 n16 vdd vdd sky130_fd_pr__pfet_01v8 L=0.5 W=0.42 nf=1 ad=0.1218 as=0.1218 pd=1.42 ps=1.42 nrd=0.69047619047619
+ nrs=0.69047619047619 sa=0 sb=0 sd=0 mult=1 m=1
XMn186 n17 n16 vss vss sky130_fd_pr__nfet_01v8 L=0.15 W=3.0 nf=1 ad=0.87 as=0.87 pd=6.58 ps=6.58 nrd=0.0966666666666667
+ nrs=0.0966666666666667 sa=0 sb=0 sd=0 mult=1 m=1
XMp191 n18 n17 vdd vdd sky130_fd_pr__pfet_01v8 L=0.5 W=0.42 nf=1 ad=0.1218 as=0.1218 pd=1.42 ps=1.42 nrd=0.69047619047619
+ nrs=0.69047619047619 sa=0 sb=0 sd=0 mult=1 m=1
XMn196 n18 n17 vss vss sky130_fd_pr__nfet_01v8 L=0.15 W=3.0 nf=1 ad=0.87 as=0.87 pd=6.58 ps=6.58 nrd=0.0966666666666667
+ nrs=0.0966666666666667 sa=0 sb=0 sd=0 mult=1 m=1
XMp201 n19 n18 vdd vdd sky130_fd_pr__pfet_01v8 L=0.5 W=0.42 nf=1 ad=0.1218 as=0.1218 pd=1.42 ps=1.42 nrd=0.69047619047619
+ nrs=0.69047619047619 sa=0 sb=0 sd=0 mult=1 m=1
XMn206 n19 n18 vss vss sky130_fd_pr__nfet_01v8 L=0.15 W=3.0 nf=1 ad=0.87 as=0.87 pd=6.58 ps=6.58 nrd=0.0966666666666667
+ nrs=0.0966666666666667 sa=0 sb=0 sd=0 mult=1 m=1
XMp211 n20 n19 vdd vdd sky130_fd_pr__pfet_01v8 L=0.5 W=0.42 nf=1 ad=0.1218 as=0.1218 pd=1.42 ps=1.42 nrd=0.69047619047619
+ nrs=0.69047619047619 sa=0 sb=0 sd=0 mult=1 m=1
XMn216 n20 n19 vss vss sky130_fd_pr__nfet_01v8 L=0.15 W=3.0 nf=1 ad=0.87 as=0.87 pd=6.58 ps=6.58 nrd=0.0966666666666667
+ nrs=0.0966666666666667 sa=0 sb=0 sd=0 mult=1 m=1
XMp221 n21 n20 vdd vdd sky130_fd_pr__pfet_01v8 L=0.5 W=0.42 nf=1 ad=0.1218 as=0.1218 pd=1.42 ps=1.42 nrd=0.69047619047619
+ nrs=0.69047619047619 sa=0 sb=0 sd=0 mult=1 m=1
XMn226 n21 n20 vss vss sky130_fd_pr__nfet_01v8 L=0.15 W=3.0 nf=1 ad=0.87 as=0.87 pd=6.58 ps=6.58 nrd=0.0966666666666667
+ nrs=0.0966666666666667 sa=0 sb=0 sd=0 mult=1 m=1
XMp231 n22 n21 vdd vdd sky130_fd_pr__pfet_01v8 L=0.5 W=0.42 nf=1 ad=0.1218 as=0.1218 pd=1.42 ps=1.42 nrd=0.69047619047619
+ nrs=0.69047619047619 sa=0 sb=0 sd=0 mult=1 m=1
XMn236 n22 n21 vss vss sky130_fd_pr__nfet_01v8 L=0.15 W=3.0 nf=1 ad=0.87 as=0.87 pd=6.58 ps=6.58 nrd=0.0966666666666667
+ nrs=0.0966666666666667 sa=0 sb=0 sd=0 mult=1 m=1
XMp241 n23 n22 vdd vdd sky130_fd_pr__pfet_01v8 L=0.5 W=0.42 nf=1 ad=0.1218 as=0.1218 pd=1.42 ps=1.42 nrd=0.69047619047619
+ nrs=0.69047619047619 sa=0 sb=0 sd=0 mult=1 m=1
XMn246 n23 n22 vss vss sky130_fd_pr__nfet_01v8 L=0.15 W=3.0 nf=1 ad=0.87 as=0.87 pd=6.58 ps=6.58 nrd=0.0966666666666667
+ nrs=0.0966666666666667 sa=0 sb=0 sd=0 mult=1 m=1
XMp251 n24 n23 vdd vdd sky130_fd_pr__pfet_01v8 L=0.5 W=0.42 nf=1 ad=0.1218 as=0.1218 pd=1.42 ps=1.42 nrd=0.69047619047619
+ nrs=0.69047619047619 sa=0 sb=0 sd=0 mult=1 m=1
XMn256 n24 n23 vss vss sky130_fd_pr__nfet_01v8 L=0.15 W=3.0 nf=1 ad=0.87 as=0.87 pd=6.58 ps=6.58 nrd=0.0966666666666667
+ nrs=0.0966666666666667 sa=0 sb=0 sd=0 mult=1 m=1
XMp261 n25 n24 vdd vdd sky130_fd_pr__pfet_01v8 L=0.5 W=0.42 nf=1 ad=0.1218 as=0.1218 pd=1.42 ps=1.42 nrd=0.69047619047619
+ nrs=0.69047619047619 sa=0 sb=0 sd=0 mult=1 m=1
XMn266 n25 n24 vss vss sky130_fd_pr__nfet_01v8 L=0.15 W=3.0 nf=1 ad=0.87 as=0.87 pd=6.58 ps=6.58 nrd=0.0966666666666667
+ nrs=0.0966666666666667 sa=0 sb=0 sd=0 mult=1 m=1
XMp271 n26 n25 vdd vdd sky130_fd_pr__pfet_01v8 L=0.5 W=0.42 nf=1 ad=0.1218 as=0.1218 pd=1.42 ps=1.42 nrd=0.69047619047619
+ nrs=0.69047619047619 sa=0 sb=0 sd=0 mult=1 m=1
XMn276 n26 n25 vss vss sky130_fd_pr__nfet_01v8 L=0.15 W=3.0 nf=1 ad=0.87 as=0.87 pd=6.58 ps=6.58 nrd=0.0966666666666667
+ nrs=0.0966666666666667 sa=0 sb=0 sd=0 mult=1 m=1
XMp281 n27 n26 vdd vdd sky130_fd_pr__pfet_01v8 L=0.5 W=0.42 nf=1 ad=0.1218 as=0.1218 pd=1.42 ps=1.42 nrd=0.69047619047619
+ nrs=0.69047619047619 sa=0 sb=0 sd=0 mult=1 m=1
XMn286 n27 n26 vss vss sky130_fd_pr__nfet_01v8 L=0.15 W=3.0 nf=1 ad=0.87 as=0.87 pd=6.58 ps=6.58 nrd=0.0966666666666667
+ nrs=0.0966666666666667 sa=0 sb=0 sd=0 mult=1 m=1
XMp291 n28 n27 vdd vdd sky130_fd_pr__pfet_01v8 L=0.5 W=0.42 nf=1 ad=0.1218 as=0.1218 pd=1.42 ps=1.42 nrd=0.69047619047619
+ nrs=0.69047619047619 sa=0 sb=0 sd=0 mult=1 m=1
XMn296 n28 n27 vss vss sky130_fd_pr__nfet_01v8 L=0.15 W=3.0 nf=1 ad=0.87 as=0.87 pd=6.58 ps=6.58 nrd=0.0966666666666667
+ nrs=0.0966666666666667 sa=0 sb=0 sd=0 mult=1 m=1
XMp301 n29 n28 vdd vdd sky130_fd_pr__pfet_01v8 L=0.5 W=0.42 nf=1 ad=0.1218 as=0.1218 pd=1.42 ps=1.42 nrd=0.69047619047619
+ nrs=0.69047619047619 sa=0 sb=0 sd=0 mult=1 m=1
XMn306 n29 n28 vss vss sky130_fd_pr__nfet_01v8 L=0.15 W=3.0 nf=1 ad=0.87 as=0.87 pd=6.58 ps=6.58 nrd=0.0966666666666667
+ nrs=0.0966666666666667 sa=0 sb=0 sd=0 mult=1 m=1
XMp311 out n29 vdd vdd sky130_fd_pr__pfet_01v8 L=0.5 W=0.42 nf=1 ad=0.1218 as=0.1218 pd=1.42 ps=1.42 nrd=0.69047619047619
+ nrs=0.69047619047619 sa=0 sb=0 sd=0 mult=1 m=1
XMn316 out n29 vss vss sky130_fd_pr__nfet_01v8 L=0.15 W=3.0 nf=1 ad=0.87 as=0.87 pd=6.58 ps=6.58 nrd=0.0966666666666667
+ nrs=0.0966666666666667 sa=0 sb=0 sd=0 mult=1 m=1
.ends
